* e) dzielnik FB TLV62569: R3/R4 z obwod.py, idealny wzmacniacz błędu, kopii: 2000
Vr0 ref0 0 0.606742739
E0 out0 0 ref0 fb0 1e6
R3_0 out0 fb0 100713.548
R4_0 fb0 0 21868.3925
Rl0 out0 0 10
Vr1 ref1 0 0.601080404
E1 out1 0 ref1 fb1 1e6
R3_1 out1 fb1 100727.044
R4_1 fb1 0 22001.0234
Rl1 out1 0 10
Vr2 ref2 0 0.589344333
E2 out2 0 ref2 fb2 1e6
R3_2 out2 fb2 99231.159
R4_2 fb2 0 21877.1545
Rl2 out2 0 10
Vr3 ref3 0 0.608419735
E3 out3 0 ref3 fb3 1e6
R3_3 out3 fb3 99545.2868
R4_3 fb3 0 22033.3357
Rl3 out3 0 10
Vr4 ref4 0 0.610143492
E4 out4 0 ref4 fb4 1e6
R3_4 out4 fb4 99371.3878
R4_4 fb4 0 22017.4579
Rl4 out4 0 10
Vr5 ref5 0 0.609542703
E5 out5 0 ref5 fb5 1e6
R3_5 out5 fb5 99479.1583
R4_5 fb5 0 22130.9657
Rl5 out5 0 10
Vr6 ref6 0 0.610268713
E6 out6 0 ref6 fb6 1e6
R3_6 out6 fb6 99221.8428
R4_6 fb6 0 22039.0016
Rl6 out6 0 10
Vr7 ref7 0 0.609016919
E7 out7 0 ref7 fb7 1e6
R3_7 out7 fb7 100213.803
R4_7 fb7 0 22140.2071
Rl7 out7 0 10
Vr8 ref8 0 0.590314423
E8 out8 0 ref8 fb8 1e6
R3_8 out8 fb8 100002.716
R4_8 fb8 0 22167.4081
Rl8 out8 0 10
Vr9 ref9 0 0.607710689
E9 out9 0 ref9 fb9 1e6
R3_9 out9 fb9 100811.117
R4_9 fb9 0 21993.48
Rl9 out9 0 10
Vr10 ref10 0 0.606853674
E10 out10 0 ref10 fb10 1e6
R3_10 out10 fb10 100112.732
R4_10 fb10 0 22083.1483
Rl10 out10 0 10
Vr11 ref11 0 0.601634314
E11 out11 0 ref11 fb11 1e6
R3_11 out11 fb11 100251.055
R4_11 fb11 0 22185.9887
Rl11 out11 0 10
Vr12 ref12 0 0.605106352
E12 out12 0 ref12 fb12 1e6
R3_12 out12 fb12 99064.422
R4_12 fb12 0 22020.9868
Rl12 out12 0 10
Vr13 ref13 0 0.589389802
E13 out13 0 ref13 fb13 1e6
R3_13 out13 fb13 100804.569
R4_13 fb13 0 21822.8172
Rl13 out13 0 10
Vr14 ref14 0 0.593480318
E14 out14 0 ref14 fb14 1e6
R3_14 out14 fb14 100416.891
R4_14 fb14 0 21982.2611
Rl14 out14 0 10
Vr15 ref15 0 0.600299981
E15 out15 0 ref15 fb15 1e6
R3_15 out15 fb15 100974.72
R4_15 fb15 0 21988.362
Rl15 out15 0 10
Vr16 ref16 0 0.592742437
E16 out16 0 ref16 fb16 1e6
R3_16 out16 fb16 100737.325
R4_16 fb16 0 21969.4934
Rl16 out16 0 10
Vr17 ref17 0 0.601730679
E17 out17 0 ref17 fb17 1e6
R3_17 out17 fb17 100497.567
R4_17 fb17 0 22196.8642
Rl17 out17 0 10
Vr18 ref18 0 0.611637489
E18 out18 0 ref18 fb18 1e6
R3_18 out18 fb18 100652.031
R4_18 fb18 0 21866.9101
Rl18 out18 0 10
Vr19 ref19 0 0.597709082
E19 out19 0 ref19 fb19 1e6
R3_19 out19 fb19 99267.55
R4_19 fb19 0 21831.9343
Rl19 out19 0 10
Vr20 ref20 0 0.596982198
E20 out20 0 ref20 fb20 1e6
R3_20 out20 fb20 99401.7527
R4_20 fb20 0 22173.5707
Rl20 out20 0 10
Vr21 ref21 0 0.590778393
E21 out21 0 ref21 fb21 1e6
R3_21 out21 fb21 100407.041
R4_21 fb21 0 21869.7702
Rl21 out21 0 10
Vr22 ref22 0 0.593561554
E22 out22 0 ref22 fb22 1e6
R3_22 out22 fb22 100178.017
R4_22 fb22 0 22053.6649
Rl22 out22 0 10
Vr23 ref23 0 0.589917729
E23 out23 0 ref23 fb23 1e6
R3_23 out23 fb23 99301.1484
R4_23 fb23 0 22002.6534
Rl23 out23 0 10
Vr24 ref24 0 0.60449513
E24 out24 0 ref24 fb24 1e6
R3_24 out24 fb24 100929.02
R4_24 fb24 0 21937.9706
Rl24 out24 0 10
Vr25 ref25 0 0.61015855
E25 out25 0 ref25 fb25 1e6
R3_25 out25 fb25 99820.2454
R4_25 fb25 0 21955.7783
Rl25 out25 0 10
Vr26 ref26 0 0.607419928
E26 out26 0 ref26 fb26 1e6
R3_26 out26 fb26 100193.464
R4_26 fb26 0 21976.1469
Rl26 out26 0 10
Vr27 ref27 0 0.60811389
E27 out27 0 ref27 fb27 1e6
R3_27 out27 fb27 99513.338
R4_27 fb27 0 21947.2437
Rl27 out27 0 10
Vr28 ref28 0 0.6098083
E28 out28 0 ref28 fb28 1e6
R3_28 out28 fb28 99640.4788
R4_28 fb28 0 21789.5456
Rl28 out28 0 10
Vr29 ref29 0 0.601296615
E29 out29 0 ref29 fb29 1e6
R3_29 out29 fb29 99084.414
R4_29 fb29 0 22178.1812
Rl29 out29 0 10
Vr30 ref30 0 0.611858596
E30 out30 0 ref30 fb30 1e6
R3_30 out30 fb30 100453.1
R4_30 fb30 0 22198.6717
Rl30 out30 0 10
Vr31 ref31 0 0.597506752
E31 out31 0 ref31 fb31 1e6
R3_31 out31 fb31 99090.2706
R4_31 fb31 0 22119.2172
Rl31 out31 0 10
Vr32 ref32 0 0.607631001
E32 out32 0 ref32 fb32 1e6
R3_32 out32 fb32 100502.716
R4_32 fb32 0 21946.2837
Rl32 out32 0 10
Vr33 ref33 0 0.598711343
E33 out33 0 ref33 fb33 1e6
R3_33 out33 fb33 100584.999
R4_33 fb33 0 21827.0101
Rl33 out33 0 10
Vr34 ref34 0 0.592862898
E34 out34 0 ref34 fb34 1e6
R3_34 out34 fb34 99309.7495
R4_34 fb34 0 21825.2379
Rl34 out34 0 10
Vr35 ref35 0 0.609222904
E35 out35 0 ref35 fb35 1e6
R3_35 out35 fb35 99335.3974
R4_35 fb35 0 22208.9951
Rl35 out35 0 10
Vr36 ref36 0 0.589165746
E36 out36 0 ref36 fb36 1e6
R3_36 out36 fb36 100636.198
R4_36 fb36 0 22170.5453
Rl36 out36 0 10
Vr37 ref37 0 0.602796498
E37 out37 0 ref37 fb37 1e6
R3_37 out37 fb37 100432.91
R4_37 fb37 0 21852.7145
Rl37 out37 0 10
Vr38 ref38 0 0.594710497
E38 out38 0 ref38 fb38 1e6
R3_38 out38 fb38 100220.113
R4_38 fb38 0 22052.3051
Rl38 out38 0 10
Vr39 ref39 0 0.601852117
E39 out39 0 ref39 fb39 1e6
R3_39 out39 fb39 99682.922
R4_39 fb39 0 22024.7448
Rl39 out39 0 10
Vr40 ref40 0 0.59222793
E40 out40 0 ref40 fb40 1e6
R3_40 out40 fb40 100498.992
R4_40 fb40 0 21804.7931
Rl40 out40 0 10
Vr41 ref41 0 0.606729149
E41 out41 0 ref41 fb41 1e6
R3_41 out41 fb41 100365.12
R4_41 fb41 0 21919.2842
Rl41 out41 0 10
Vr42 ref42 0 0.595707354
E42 out42 0 ref42 fb42 1e6
R3_42 out42 fb42 99078.3499
R4_42 fb42 0 22218.71
Rl42 out42 0 10
Vr43 ref43 0 0.604533223
E43 out43 0 ref43 fb43 1e6
R3_43 out43 fb43 100559.122
R4_43 fb43 0 22215.1545
Rl43 out43 0 10
Vr44 ref44 0 0.59102692
E44 out44 0 ref44 fb44 1e6
R3_44 out44 fb44 100658.943
R4_44 fb44 0 21872.1702
Rl44 out44 0 10
Vr45 ref45 0 0.602101023
E45 out45 0 ref45 fb45 1e6
R3_45 out45 fb45 100431.011
R4_45 fb45 0 22066.5452
Rl45 out45 0 10
Vr46 ref46 0 0.591597757
E46 out46 0 ref46 fb46 1e6
R3_46 out46 fb46 99713.3584
R4_46 fb46 0 21953.8342
Rl46 out46 0 10
Vr47 ref47 0 0.598769962
E47 out47 0 ref47 fb47 1e6
R3_47 out47 fb47 99515.2083
R4_47 fb47 0 21918.2947
Rl47 out47 0 10
Vr48 ref48 0 0.607541735
E48 out48 0 ref48 fb48 1e6
R3_48 out48 fb48 99514.304
R4_48 fb48 0 22018.3007
Rl48 out48 0 10
Vr49 ref49 0 0.600318415
E49 out49 0 ref49 fb49 1e6
R3_49 out49 fb49 99444.9739
R4_49 fb49 0 22099.8222
Rl49 out49 0 10
Vr50 ref50 0 0.58880916
E50 out50 0 ref50 fb50 1e6
R3_50 out50 fb50 100243.92
R4_50 fb50 0 21804.0884
Rl50 out50 0 10
Vr51 ref51 0 0.603859759
E51 out51 0 ref51 fb51 1e6
R3_51 out51 fb51 100146.504
R4_51 fb51 0 21818.3168
Rl51 out51 0 10
Vr52 ref52 0 0.594536025
E52 out52 0 ref52 fb52 1e6
R3_52 out52 fb52 100207.121
R4_52 fb52 0 22104.8661
Rl52 out52 0 10
Vr53 ref53 0 0.597112851
E53 out53 0 ref53 fb53 1e6
R3_53 out53 fb53 100950.715
R4_53 fb53 0 21837.7282
Rl53 out53 0 10
Vr54 ref54 0 0.59212998
E54 out54 0 ref54 fb54 1e6
R3_54 out54 fb54 100197.551
R4_54 fb54 0 21956.2503
Rl54 out54 0 10
Vr55 ref55 0 0.610983711
E55 out55 0 ref55 fb55 1e6
R3_55 out55 fb55 100479.859
R4_55 fb55 0 21847.6435
Rl55 out55 0 10
Vr56 ref56 0 0.59245069
E56 out56 0 ref56 fb56 1e6
R3_56 out56 fb56 99779.9848
R4_56 fb56 0 22152.1331
Rl56 out56 0 10
Vr57 ref57 0 0.609341096
E57 out57 0 ref57 fb57 1e6
R3_57 out57 fb57 100104.02
R4_57 fb57 0 22055.439
Rl57 out57 0 10
Vr58 ref58 0 0.60181785
E58 out58 0 ref58 fb58 1e6
R3_58 out58 fb58 100909.311
R4_58 fb58 0 21839.1837
Rl58 out58 0 10
Vr59 ref59 0 0.60307259
E59 out59 0 ref59 fb59 1e6
R3_59 out59 fb59 100268.719
R4_59 fb59 0 21976.0867
Rl59 out59 0 10
Vr60 ref60 0 0.609639181
E60 out60 0 ref60 fb60 1e6
R3_60 out60 fb60 99081.3254
R4_60 fb60 0 21939.5641
Rl60 out60 0 10
Vr61 ref61 0 0.611137771
E61 out61 0 ref61 fb61 1e6
R3_61 out61 fb61 100890.235
R4_61 fb61 0 21828.5491
Rl61 out61 0 10
Vr62 ref62 0 0.608922638
E62 out62 0 ref62 fb62 1e6
R3_62 out62 fb62 100895.19
R4_62 fb62 0 22108.6172
Rl62 out62 0 10
Vr63 ref63 0 0.603697753
E63 out63 0 ref63 fb63 1e6
R3_63 out63 fb63 100015.676
R4_63 fb63 0 22201.8531
Rl63 out63 0 10
Vr64 ref64 0 0.609204471
E64 out64 0 ref64 fb64 1e6
R3_64 out64 fb64 99863.9569
R4_64 fb64 0 21787.0467
Rl64 out64 0 10
Vr65 ref65 0 0.592647504
E65 out65 0 ref65 fb65 1e6
R3_65 out65 fb65 100438.958
R4_65 fb65 0 22071.3761
Rl65 out65 0 10
Vr66 ref66 0 0.59038878
E66 out66 0 ref66 fb66 1e6
R3_66 out66 fb66 100515.348
R4_66 fb66 0 22218.7279
Rl66 out66 0 10
Vr67 ref67 0 0.608495937
E67 out67 0 ref67 fb67 1e6
R3_67 out67 fb67 99284.9329
R4_67 fb67 0 21922.1656
Rl67 out67 0 10
Vr68 ref68 0 0.588139199
E68 out68 0 ref68 fb68 1e6
R3_68 out68 fb68 100676.267
R4_68 fb68 0 21850.6855
Rl68 out68 0 10
Vr69 ref69 0 0.602789024
E69 out69 0 ref69 fb69 1e6
R3_69 out69 fb69 100563.174
R4_69 fb69 0 22151.6287
Rl69 out69 0 10
Vr70 ref70 0 0.59193276
E70 out70 0 ref70 fb70 1e6
R3_70 out70 fb70 100406.385
R4_70 fb70 0 22188.3437
Rl70 out70 0 10
Vr71 ref71 0 0.608970163
E71 out71 0 ref71 fb71 1e6
R3_71 out71 fb71 99304.5847
R4_71 fb71 0 22088.0179
Rl71 out71 0 10
Vr72 ref72 0 0.593600608
E72 out72 0 ref72 fb72 1e6
R3_72 out72 fb72 99188.9574
R4_72 fb72 0 22202.2883
Rl72 out72 0 10
Vr73 ref73 0 0.61156898
E73 out73 0 ref73 fb73 1e6
R3_73 out73 fb73 99801.5215
R4_73 fb73 0 21788.8883
Rl73 out73 0 10
Vr74 ref74 0 0.605849732
E74 out74 0 ref74 fb74 1e6
R3_74 out74 fb74 100564.309
R4_74 fb74 0 21874.4039
Rl74 out74 0 10
Vr75 ref75 0 0.601911752
E75 out75 0 ref75 fb75 1e6
R3_75 out75 fb75 99595.5587
R4_75 fb75 0 21792.4059
Rl75 out75 0 10
Vr76 ref76 0 0.591451961
E76 out76 0 ref76 fb76 1e6
R3_76 out76 fb76 99881.9814
R4_76 fb76 0 22064.4038
Rl76 out76 0 10
Vr77 ref77 0 0.59181021
E77 out77 0 ref77 fb77 1e6
R3_77 out77 fb77 100077.022
R4_77 fb77 0 21931.8994
Rl77 out77 0 10
Vr78 ref78 0 0.607553532
E78 out78 0 ref78 fb78 1e6
R3_78 out78 fb78 100722.567
R4_78 fb78 0 21786.9742
Rl78 out78 0 10
Vr79 ref79 0 0.59720717
E79 out79 0 ref79 fb79 1e6
R3_79 out79 fb79 99078.231
R4_79 fb79 0 22175.2304
Rl79 out79 0 10
Vr80 ref80 0 0.595330011
E80 out80 0 ref80 fb80 1e6
R3_80 out80 fb80 100947.351
R4_80 fb80 0 22107.3586
Rl80 out80 0 10
Vr81 ref81 0 0.5944547
E81 out81 0 ref81 fb81 1e6
R3_81 out81 fb81 99186.8531
R4_81 fb81 0 22202.9267
Rl81 out81 0 10
Vr82 ref82 0 0.607583994
E82 out82 0 ref82 fb82 1e6
R3_82 out82 fb82 100232.722
R4_82 fb82 0 21781.1166
Rl82 out82 0 10
Vr83 ref83 0 0.606999147
E83 out83 0 ref83 fb83 1e6
R3_83 out83 fb83 100855.014
R4_83 fb83 0 22204.9818
Rl83 out83 0 10
Vr84 ref84 0 0.591451458
E84 out84 0 ref84 fb84 1e6
R3_84 out84 fb84 100627.466
R4_84 fb84 0 22205.4382
Rl84 out84 0 10
Vr85 ref85 0 0.600779957
E85 out85 0 ref85 fb85 1e6
R3_85 out85 fb85 99817.6268
R4_85 fb85 0 22120.6942
Rl85 out85 0 10
Vr86 ref86 0 0.601699679
E86 out86 0 ref86 fb86 1e6
R3_86 out86 fb86 99446.1179
R4_86 fb86 0 22197.8279
Rl86 out86 0 10
Vr87 ref87 0 0.589712125
E87 out87 0 ref87 fb87 1e6
R3_87 out87 fb87 99300.2713
R4_87 fb87 0 21972.6295
Rl87 out87 0 10
Vr88 ref88 0 0.60146192
E88 out88 0 ref88 fb88 1e6
R3_88 out88 fb88 100915.22
R4_88 fb88 0 22112.1004
Rl88 out88 0 10
Vr89 ref89 0 0.594848939
E89 out89 0 ref89 fb89 1e6
R3_89 out89 fb89 100220.844
R4_89 fb89 0 21988.5187
Rl89 out89 0 10
Vr90 ref90 0 0.593614409
E90 out90 0 ref90 fb90 1e6
R3_90 out90 fb90 99874.7713
R4_90 fb90 0 21862.1768
Rl90 out90 0 10
Vr91 ref91 0 0.595135097
E91 out91 0 ref91 fb91 1e6
R3_91 out91 fb91 99892.7992
R4_91 fb91 0 22131.4474
Rl91 out91 0 10
Vr92 ref92 0 0.609268787
E92 out92 0 ref92 fb92 1e6
R3_92 out92 fb92 99081.9209
R4_92 fb92 0 21961.6829
Rl92 out92 0 10
Vr93 ref93 0 0.611452773
E93 out93 0 ref93 fb93 1e6
R3_93 out93 fb93 100546.629
R4_93 fb93 0 21953.5271
Rl93 out93 0 10
Vr94 ref94 0 0.60067174
E94 out94 0 ref94 fb94 1e6
R3_94 out94 fb94 99538.7132
R4_94 fb94 0 22004.2209
Rl94 out94 0 10
Vr95 ref95 0 0.591487881
E95 out95 0 ref95 fb95 1e6
R3_95 out95 fb95 99997.2458
R4_95 fb95 0 21871.7101
Rl95 out95 0 10
Vr96 ref96 0 0.603474168
E96 out96 0 ref96 fb96 1e6
R3_96 out96 fb96 99507.946
R4_96 fb96 0 22151.1949
Rl96 out96 0 10
Vr97 ref97 0 0.590454689
E97 out97 0 ref97 fb97 1e6
R3_97 out97 fb97 100293.835
R4_97 fb97 0 21809.9058
Rl97 out97 0 10
Vr98 ref98 0 0.595570667
E98 out98 0 ref98 fb98 1e6
R3_98 out98 fb98 100013.618
R4_98 fb98 0 21791.0495
Rl98 out98 0 10
Vr99 ref99 0 0.597420132
E99 out99 0 ref99 fb99 1e6
R3_99 out99 fb99 99660.095
R4_99 fb99 0 21921.5617
Rl99 out99 0 10
Vr100 ref100 0 0.590711222
E100 out100 0 ref100 fb100 1e6
R3_100 out100 fb100 99021.0672
R4_100 fb100 0 22159.8759
Rl100 out100 0 10
Vr101 ref101 0 0.609272893
E101 out101 0 ref101 fb101 1e6
R3_101 out101 fb101 99041.0675
R4_101 fb101 0 21839.0476
Rl101 out101 0 10
Vr102 ref102 0 0.595777167
E102 out102 0 ref102 fb102 1e6
R3_102 out102 fb102 99808.0363
R4_102 fb102 0 22151.4635
Rl102 out102 0 10
Vr103 ref103 0 0.611803496
E103 out103 0 ref103 fb103 1e6
R3_103 out103 fb103 100341.092
R4_103 fb103 0 22067.2758
Rl103 out103 0 10
Vr104 ref104 0 0.59534502
E104 out104 0 ref104 fb104 1e6
R3_104 out104 fb104 100157.739
R4_104 fb104 0 21972.9313
Rl104 out104 0 10
Vr105 ref105 0 0.600553613
E105 out105 0 ref105 fb105 1e6
R3_105 out105 fb105 100798.028
R4_105 fb105 0 21849.5447
Rl105 out105 0 10
Vr106 ref106 0 0.601486224
E106 out106 0 ref106 fb106 1e6
R3_106 out106 fb106 99019.4514
R4_106 fb106 0 21868.9935
Rl106 out106 0 10
Vr107 ref107 0 0.595509374
E107 out107 0 ref107 fb107 1e6
R3_107 out107 fb107 99895.8154
R4_107 fb107 0 21999.6121
Rl107 out107 0 10
Vr108 ref108 0 0.605391961
E108 out108 0 ref108 fb108 1e6
R3_108 out108 fb108 99618.8335
R4_108 fb108 0 22002.2285
Rl108 out108 0 10
Vr109 ref109 0 0.601868284
E109 out109 0 ref109 fb109 1e6
R3_109 out109 fb109 100382.174
R4_109 fb109 0 22164.602
Rl109 out109 0 10
Vr110 ref110 0 0.591345989
E110 out110 0 ref110 fb110 1e6
R3_110 out110 fb110 99980.4871
R4_110 fb110 0 22048.4852
Rl110 out110 0 10
Vr111 ref111 0 0.593858848
E111 out111 0 ref111 fb111 1e6
R3_111 out111 fb111 99327.6603
R4_111 fb111 0 21784.4774
Rl111 out111 0 10
Vr112 ref112 0 0.596725136
E112 out112 0 ref112 fb112 1e6
R3_112 out112 fb112 99163.8412
R4_112 fb112 0 21927.9589
Rl112 out112 0 10
Vr113 ref113 0 0.603514476
E113 out113 0 ref113 fb113 1e6
R3_113 out113 fb113 99070.2656
R4_113 fb113 0 22010.0734
Rl113 out113 0 10
Vr114 ref114 0 0.591900277
E114 out114 0 ref114 fb114 1e6
R3_114 out114 fb114 99147.4327
R4_114 fb114 0 22047.8259
Rl114 out114 0 10
Vr115 ref115 0 0.60380222
E115 out115 0 ref115 fb115 1e6
R3_115 out115 fb115 99889.922
R4_115 fb115 0 21975.1144
Rl115 out115 0 10
Vr116 ref116 0 0.606568595
E116 out116 0 ref116 fb116 1e6
R3_116 out116 fb116 99181.4521
R4_116 fb116 0 21795.0381
Rl116 out116 0 10
Vr117 ref117 0 0.609865819
E117 out117 0 ref117 fb117 1e6
R3_117 out117 fb117 99443.4096
R4_117 fb117 0 22213.9243
Rl117 out117 0 10
Vr118 ref118 0 0.599128738
E118 out118 0 ref118 fb118 1e6
R3_118 out118 fb118 100731.416
R4_118 fb118 0 21983.7373
Rl118 out118 0 10
Vr119 ref119 0 0.590579608
E119 out119 0 ref119 fb119 1e6
R3_119 out119 fb119 99644.5311
R4_119 fb119 0 21920.8284
Rl119 out119 0 10
Vr120 ref120 0 0.600110807
E120 out120 0 ref120 fb120 1e6
R3_120 out120 fb120 100129.951
R4_120 fb120 0 22111.9903
Rl120 out120 0 10
Vr121 ref121 0 0.607581809
E121 out121 0 ref121 fb121 1e6
R3_121 out121 fb121 99944.6219
R4_121 fb121 0 22112.6278
Rl121 out121 0 10
Vr122 ref122 0 0.59894283
E122 out122 0 ref122 fb122 1e6
R3_122 out122 fb122 100060.835
R4_122 fb122 0 22062.7692
Rl122 out122 0 10
Vr123 ref123 0 0.604909929
E123 out123 0 ref123 fb123 1e6
R3_123 out123 fb123 100679.786
R4_123 fb123 0 21991.0416
Rl123 out123 0 10
Vr124 ref124 0 0.602344773
E124 out124 0 ref124 fb124 1e6
R3_124 out124 fb124 99748.1738
R4_124 fb124 0 22123.4403
Rl124 out124 0 10
Vr125 ref125 0 0.604447185
E125 out125 0 ref125 fb125 1e6
R3_125 out125 fb125 100833.119
R4_125 fb125 0 22045.1749
Rl125 out125 0 10
Vr126 ref126 0 0.593406262
E126 out126 0 ref126 fb126 1e6
R3_126 out126 fb126 100627.885
R4_126 fb126 0 21788.2781
Rl126 out126 0 10
Vr127 ref127 0 0.598998409
E127 out127 0 ref127 fb127 1e6
R3_127 out127 fb127 99237.8439
R4_127 fb127 0 21867.2638
Rl127 out127 0 10
Vr128 ref128 0 0.59504654
E128 out128 0 ref128 fb128 1e6
R3_128 out128 fb128 99584.7312
R4_128 fb128 0 22169.8501
Rl128 out128 0 10
Vr129 ref129 0 0.603231294
E129 out129 0 ref129 fb129 1e6
R3_129 out129 fb129 99395.3637
R4_129 fb129 0 21993.7481
Rl129 out129 0 10
Vr130 ref130 0 0.606154329
E130 out130 0 ref130 fb130 1e6
R3_130 out130 fb130 99153.2725
R4_130 fb130 0 22183.4618
Rl130 out130 0 10
Vr131 ref131 0 0.604740095
E131 out131 0 ref131 fb131 1e6
R3_131 out131 fb131 100582.097
R4_131 fb131 0 21866.0737
Rl131 out131 0 10
Vr132 ref132 0 0.603036241
E132 out132 0 ref132 fb132 1e6
R3_132 out132 fb132 99242.1047
R4_132 fb132 0 21924.3976
Rl132 out132 0 10
Vr133 ref133 0 0.603708307
E133 out133 0 ref133 fb133 1e6
R3_133 out133 fb133 100354.727
R4_133 fb133 0 22208.0397
Rl133 out133 0 10
Vr134 ref134 0 0.611018436
E134 out134 0 ref134 fb134 1e6
R3_134 out134 fb134 100982.888
R4_134 fb134 0 21805.2841
Rl134 out134 0 10
Vr135 ref135 0 0.607143445
E135 out135 0 ref135 fb135 1e6
R3_135 out135 fb135 100937.032
R4_135 fb135 0 22195.3002
Rl135 out135 0 10
Vr136 ref136 0 0.589396311
E136 out136 0 ref136 fb136 1e6
R3_136 out136 fb136 100047.036
R4_136 fb136 0 21872.3831
Rl136 out136 0 10
Vr137 ref137 0 0.601422457
E137 out137 0 ref137 fb137 1e6
R3_137 out137 fb137 99761.5241
R4_137 fb137 0 21987.6492
Rl137 out137 0 10
Vr138 ref138 0 0.610389389
E138 out138 0 ref138 fb138 1e6
R3_138 out138 fb138 99919.5463
R4_138 fb138 0 22014.5558
Rl138 out138 0 10
Vr139 ref139 0 0.597182403
E139 out139 0 ref139 fb139 1e6
R3_139 out139 fb139 100390.158
R4_139 fb139 0 22187.1672
Rl139 out139 0 10
Vr140 ref140 0 0.591925584
E140 out140 0 ref140 fb140 1e6
R3_140 out140 fb140 99797.428
R4_140 fb140 0 22095.2128
Rl140 out140 0 10
Vr141 ref141 0 0.59300133
E141 out141 0 ref141 fb141 1e6
R3_141 out141 fb141 100596.91
R4_141 fb141 0 21859.0919
Rl141 out141 0 10
Vr142 ref142 0 0.609081085
E142 out142 0 ref142 fb142 1e6
R3_142 out142 fb142 100606.953
R4_142 fb142 0 22118.5961
Rl142 out142 0 10
Vr143 ref143 0 0.594603451
E143 out143 0 ref143 fb143 1e6
R3_143 out143 fb143 99436.4154
R4_143 fb143 0 21802.9075
Rl143 out143 0 10
Vr144 ref144 0 0.608135537
E144 out144 0 ref144 fb144 1e6
R3_144 out144 fb144 99122.8617
R4_144 fb144 0 22216.2521
Rl144 out144 0 10
Vr145 ref145 0 0.608411274
E145 out145 0 ref145 fb145 1e6
R3_145 out145 fb145 99027.6006
R4_145 fb145 0 22037.6662
Rl145 out145 0 10
Vr146 ref146 0 0.590207486
E146 out146 0 ref146 fb146 1e6
R3_146 out146 fb146 99911.3323
R4_146 fb146 0 21781.1269
Rl146 out146 0 10
Vr147 ref147 0 0.592161341
E147 out147 0 ref147 fb147 1e6
R3_147 out147 fb147 100358.037
R4_147 fb147 0 22007.0921
Rl147 out147 0 10
Vr148 ref148 0 0.595442866
E148 out148 0 ref148 fb148 1e6
R3_148 out148 fb148 100118.527
R4_148 fb148 0 22125.985
Rl148 out148 0 10
Vr149 ref149 0 0.602524587
E149 out149 0 ref149 fb149 1e6
R3_149 out149 fb149 99947.6407
R4_149 fb149 0 22210.2779
Rl149 out149 0 10
Vr150 ref150 0 0.595873383
E150 out150 0 ref150 fb150 1e6
R3_150 out150 fb150 99881.58
R4_150 fb150 0 21995.5581
Rl150 out150 0 10
Vr151 ref151 0 0.602572279
E151 out151 0 ref151 fb151 1e6
R3_151 out151 fb151 100502.527
R4_151 fb151 0 22081.4145
Rl151 out151 0 10
Vr152 ref152 0 0.605234362
E152 out152 0 ref152 fb152 1e6
R3_152 out152 fb152 99125.2402
R4_152 fb152 0 22140.349
Rl152 out152 0 10
Vr153 ref153 0 0.59298639
E153 out153 0 ref153 fb153 1e6
R3_153 out153 fb153 99228.6498
R4_153 fb153 0 21913.6143
Rl153 out153 0 10
Vr154 ref154 0 0.602498436
E154 out154 0 ref154 fb154 1e6
R3_154 out154 fb154 100106.65
R4_154 fb154 0 22201
Rl154 out154 0 10
Vr155 ref155 0 0.594384581
E155 out155 0 ref155 fb155 1e6
R3_155 out155 fb155 100511.517
R4_155 fb155 0 21963.7511
Rl155 out155 0 10
Vr156 ref156 0 0.60484288
E156 out156 0 ref156 fb156 1e6
R3_156 out156 fb156 100755.452
R4_156 fb156 0 22146.2076
Rl156 out156 0 10
Vr157 ref157 0 0.611383558
E157 out157 0 ref157 fb157 1e6
R3_157 out157 fb157 99308.4336
R4_157 fb157 0 21845.849
Rl157 out157 0 10
Vr158 ref158 0 0.596128665
E158 out158 0 ref158 fb158 1e6
R3_158 out158 fb158 99817.7832
R4_158 fb158 0 21884.6831
Rl158 out158 0 10
Vr159 ref159 0 0.610428097
E159 out159 0 ref159 fb159 1e6
R3_159 out159 fb159 99606.8497
R4_159 fb159 0 22116.2675
Rl159 out159 0 10
Vr160 ref160 0 0.607352222
E160 out160 0 ref160 fb160 1e6
R3_160 out160 fb160 100925.525
R4_160 fb160 0 21925.5233
Rl160 out160 0 10
Vr161 ref161 0 0.601201627
E161 out161 0 ref161 fb161 1e6
R3_161 out161 fb161 99584.9221
R4_161 fb161 0 22134.4161
Rl161 out161 0 10
Vr162 ref162 0 0.58803359
E162 out162 0 ref162 fb162 1e6
R3_162 out162 fb162 99003.2835
R4_162 fb162 0 21996.8381
Rl162 out162 0 10
Vr163 ref163 0 0.60701681
E163 out163 0 ref163 fb163 1e6
R3_163 out163 fb163 100188.396
R4_163 fb163 0 22137.0701
Rl163 out163 0 10
Vr164 ref164 0 0.599141921
E164 out164 0 ref164 fb164 1e6
R3_164 out164 fb164 99584.9305
R4_164 fb164 0 22028.5532
Rl164 out164 0 10
Vr165 ref165 0 0.609718811
E165 out165 0 ref165 fb165 1e6
R3_165 out165 fb165 100175.584
R4_165 fb165 0 21808.802
Rl165 out165 0 10
Vr166 ref166 0 0.601655631
E166 out166 0 ref166 fb166 1e6
R3_166 out166 fb166 99866.1217
R4_166 fb166 0 21853.5774
Rl166 out166 0 10
Vr167 ref167 0 0.607850699
E167 out167 0 ref167 fb167 1e6
R3_167 out167 fb167 100620.603
R4_167 fb167 0 21839.9467
Rl167 out167 0 10
Vr168 ref168 0 0.610494887
E168 out168 0 ref168 fb168 1e6
R3_168 out168 fb168 100458.915
R4_168 fb168 0 22044.7653
Rl168 out168 0 10
Vr169 ref169 0 0.59937192
E169 out169 0 ref169 fb169 1e6
R3_169 out169 fb169 100485.276
R4_169 fb169 0 21783.6393
Rl169 out169 0 10
Vr170 ref170 0 0.606836751
E170 out170 0 ref170 fb170 1e6
R3_170 out170 fb170 99994.2988
R4_170 fb170 0 22129.9788
Rl170 out170 0 10
Vr171 ref171 0 0.60720593
E171 out171 0 ref171 fb171 1e6
R3_171 out171 fb171 99901.2254
R4_171 fb171 0 22052.1978
Rl171 out171 0 10
Vr172 ref172 0 0.594767256
E172 out172 0 ref172 fb172 1e6
R3_172 out172 fb172 100707.916
R4_172 fb172 0 21876.4466
Rl172 out172 0 10
Vr173 ref173 0 0.5904336
E173 out173 0 ref173 fb173 1e6
R3_173 out173 fb173 100212.409
R4_173 fb173 0 21819.4663
Rl173 out173 0 10
Vr174 ref174 0 0.590305983
E174 out174 0 ref174 fb174 1e6
R3_174 out174 fb174 100946.795
R4_174 fb174 0 22106.4653
Rl174 out174 0 10
Vr175 ref175 0 0.589804643
E175 out175 0 ref175 fb175 1e6
R3_175 out175 fb175 99880.9366
R4_175 fb175 0 21986.0225
Rl175 out175 0 10
Vr176 ref176 0 0.593924727
E176 out176 0 ref176 fb176 1e6
R3_176 out176 fb176 100077.627
R4_176 fb176 0 22081.3043
Rl176 out176 0 10
Vr177 ref177 0 0.592766017
E177 out177 0 ref177 fb177 1e6
R3_177 out177 fb177 100548.691
R4_177 fb177 0 22073.4843
Rl177 out177 0 10
Vr178 ref178 0 0.595901575
E178 out178 0 ref178 fb178 1e6
R3_178 out178 fb178 100678.489
R4_178 fb178 0 21818.6553
Rl178 out178 0 10
Vr179 ref179 0 0.605517457
E179 out179 0 ref179 fb179 1e6
R3_179 out179 fb179 99692.2177
R4_179 fb179 0 21853.0619
Rl179 out179 0 10
Vr180 ref180 0 0.596653332
E180 out180 0 ref180 fb180 1e6
R3_180 out180 fb180 100888.356
R4_180 fb180 0 21862.186
Rl180 out180 0 10
Vr181 ref181 0 0.590946494
E181 out181 0 ref181 fb181 1e6
R3_181 out181 fb181 99881.9785
R4_181 fb181 0 21963.764
Rl181 out181 0 10
Vr182 ref182 0 0.589925276
E182 out182 0 ref182 fb182 1e6
R3_182 out182 fb182 99359.8812
R4_182 fb182 0 22007.0979
Rl182 out182 0 10
Vr183 ref183 0 0.608141261
E183 out183 0 ref183 fb183 1e6
R3_183 out183 fb183 100525.941
R4_183 fb183 0 22112.1406
Rl183 out183 0 10
Vr184 ref184 0 0.591733205
E184 out184 0 ref184 fb184 1e6
R3_184 out184 fb184 100324.996
R4_184 fb184 0 22159.0281
Rl184 out184 0 10
Vr185 ref185 0 0.592755934
E185 out185 0 ref185 fb185 1e6
R3_185 out185 fb185 100997.125
R4_185 fb185 0 22052.6514
Rl185 out185 0 10
Vr186 ref186 0 0.588987984
E186 out186 0 ref186 fb186 1e6
R3_186 out186 fb186 99322.9351
R4_186 fb186 0 22057.3932
Rl186 out186 0 10
Vr187 ref187 0 0.603167184
E187 out187 0 ref187 fb187 1e6
R3_187 out187 fb187 99499.4647
R4_187 fb187 0 22083.3772
Rl187 out187 0 10
Vr188 ref188 0 0.608651041
E188 out188 0 ref188 fb188 1e6
R3_188 out188 fb188 99493.9799
R4_188 fb188 0 22212.9681
Rl188 out188 0 10
Vr189 ref189 0 0.589993707
E189 out189 0 ref189 fb189 1e6
R3_189 out189 fb189 100837.489
R4_189 fb189 0 21885.7673
Rl189 out189 0 10
Vr190 ref190 0 0.607832717
E190 out190 0 ref190 fb190 1e6
R3_190 out190 fb190 99412.8918
R4_190 fb190 0 22149.0855
Rl190 out190 0 10
Vr191 ref191 0 0.596002869
E191 out191 0 ref191 fb191 1e6
R3_191 out191 fb191 99087.3084
R4_191 fb191 0 22001.0506
Rl191 out191 0 10
Vr192 ref192 0 0.599605565
E192 out192 0 ref192 fb192 1e6
R3_192 out192 fb192 99792.5696
R4_192 fb192 0 22200.8719
Rl192 out192 0 10
Vr193 ref193 0 0.61196434
E193 out193 0 ref193 fb193 1e6
R3_193 out193 fb193 99652.9565
R4_193 fb193 0 22104.4088
Rl193 out193 0 10
Vr194 ref194 0 0.596455634
E194 out194 0 ref194 fb194 1e6
R3_194 out194 fb194 100418.681
R4_194 fb194 0 22025.0652
Rl194 out194 0 10
Vr195 ref195 0 0.599327981
E195 out195 0 ref195 fb195 1e6
R3_195 out195 fb195 99103.0508
R4_195 fb195 0 22194.0677
Rl195 out195 0 10
Vr196 ref196 0 0.61117758
E196 out196 0 ref196 fb196 1e6
R3_196 out196 fb196 99458.942
R4_196 fb196 0 22189.004
Rl196 out196 0 10
Vr197 ref197 0 0.600558288
E197 out197 0 ref197 fb197 1e6
R3_197 out197 fb197 99784.4941
R4_197 fb197 0 22100.9802
Rl197 out197 0 10
Vr198 ref198 0 0.608238097
E198 out198 0 ref198 fb198 1e6
R3_198 out198 fb198 99254.1578
R4_198 fb198 0 21997.7617
Rl198 out198 0 10
Vr199 ref199 0 0.592847222
E199 out199 0 ref199 fb199 1e6
R3_199 out199 fb199 99450.3432
R4_199 fb199 0 21951.9106
Rl199 out199 0 10
Vr200 ref200 0 0.597892181
E200 out200 0 ref200 fb200 1e6
R3_200 out200 fb200 99760.4125
R4_200 fb200 0 21840.7683
Rl200 out200 0 10
Vr201 ref201 0 0.608416048
E201 out201 0 ref201 fb201 1e6
R3_201 out201 fb201 100450.629
R4_201 fb201 0 21804.7803
Rl201 out201 0 10
Vr202 ref202 0 0.591386316
E202 out202 0 ref202 fb202 1e6
R3_202 out202 fb202 99336.4177
R4_202 fb202 0 22102.09
Rl202 out202 0 10
Vr203 ref203 0 0.592604611
E203 out203 0 ref203 fb203 1e6
R3_203 out203 fb203 99906.2356
R4_203 fb203 0 22044.7434
Rl203 out203 0 10
Vr204 ref204 0 0.588965015
E204 out204 0 ref204 fb204 1e6
R3_204 out204 fb204 99059.7776
R4_204 fb204 0 22051.379
Rl204 out204 0 10
Vr205 ref205 0 0.60485203
E205 out205 0 ref205 fb205 1e6
R3_205 out205 fb205 100653.261
R4_205 fb205 0 22050.4484
Rl205 out205 0 10
Vr206 ref206 0 0.610286677
E206 out206 0 ref206 fb206 1e6
R3_206 out206 fb206 99832.4566
R4_206 fb206 0 22021.5162
Rl206 out206 0 10
Vr207 ref207 0 0.601224918
E207 out207 0 ref207 fb207 1e6
R3_207 out207 fb207 99149.439
R4_207 fb207 0 21946.8231
Rl207 out207 0 10
Vr208 ref208 0 0.597844284
E208 out208 0 ref208 fb208 1e6
R3_208 out208 fb208 99131.352
R4_208 fb208 0 22113.8783
Rl208 out208 0 10
Vr209 ref209 0 0.61114351
E209 out209 0 ref209 fb209 1e6
R3_209 out209 fb209 99095.1292
R4_209 fb209 0 22016.6752
Rl209 out209 0 10
Vr210 ref210 0 0.610998731
E210 out210 0 ref210 fb210 1e6
R3_210 out210 fb210 99334.0414
R4_210 fb210 0 22123.3259
Rl210 out210 0 10
Vr211 ref211 0 0.606350161
E211 out211 0 ref211 fb211 1e6
R3_211 out211 fb211 100143.021
R4_211 fb211 0 22032.9147
Rl211 out211 0 10
Vr212 ref212 0 0.611471531
E212 out212 0 ref212 fb212 1e6
R3_212 out212 fb212 100648.885
R4_212 fb212 0 21909.67
Rl212 out212 0 10
Vr213 ref213 0 0.593129397
E213 out213 0 ref213 fb213 1e6
R3_213 out213 fb213 99907.4273
R4_213 fb213 0 21826.7542
Rl213 out213 0 10
Vr214 ref214 0 0.597607081
E214 out214 0 ref214 fb214 1e6
R3_214 out214 fb214 100342.377
R4_214 fb214 0 21785.4808
Rl214 out214 0 10
Vr215 ref215 0 0.604466187
E215 out215 0 ref215 fb215 1e6
R3_215 out215 fb215 99246.5072
R4_215 fb215 0 21929.8088
Rl215 out215 0 10
Vr216 ref216 0 0.60300115
E216 out216 0 ref216 fb216 1e6
R3_216 out216 fb216 100932.44
R4_216 fb216 0 22215.6425
Rl216 out216 0 10
Vr217 ref217 0 0.590950205
E217 out217 0 ref217 fb217 1e6
R3_217 out217 fb217 100510.788
R4_217 fb217 0 21791.9616
Rl217 out217 0 10
Vr218 ref218 0 0.607295174
E218 out218 0 ref218 fb218 1e6
R3_218 out218 fb218 100680.259
R4_218 fb218 0 22002.9164
Rl218 out218 0 10
Vr219 ref219 0 0.598072289
E219 out219 0 ref219 fb219 1e6
R3_219 out219 fb219 99893.4364
R4_219 fb219 0 22096.6015
Rl219 out219 0 10
Vr220 ref220 0 0.597597449
E220 out220 0 ref220 fb220 1e6
R3_220 out220 fb220 99030.5868
R4_220 fb220 0 21870.1704
Rl220 out220 0 10
Vr221 ref221 0 0.60305632
E221 out221 0 ref221 fb221 1e6
R3_221 out221 fb221 100365.89
R4_221 fb221 0 22169.5379
Rl221 out221 0 10
Vr222 ref222 0 0.610614261
E222 out222 0 ref222 fb222 1e6
R3_222 out222 fb222 100383.396
R4_222 fb222 0 22037.9244
Rl222 out222 0 10
Vr223 ref223 0 0.607542135
E223 out223 0 ref223 fb223 1e6
R3_223 out223 fb223 100077.521
R4_223 fb223 0 21891.8845
Rl223 out223 0 10
Vr224 ref224 0 0.601936963
E224 out224 0 ref224 fb224 1e6
R3_224 out224 fb224 99006.2885
R4_224 fb224 0 21841.3104
Rl224 out224 0 10
Vr225 ref225 0 0.589303332
E225 out225 0 ref225 fb225 1e6
R3_225 out225 fb225 99835.0987
R4_225 fb225 0 22141.6971
Rl225 out225 0 10
Vr226 ref226 0 0.609321452
E226 out226 0 ref226 fb226 1e6
R3_226 out226 fb226 100063.209
R4_226 fb226 0 21919.6812
Rl226 out226 0 10
Vr227 ref227 0 0.589279965
E227 out227 0 ref227 fb227 1e6
R3_227 out227 fb227 100862.215
R4_227 fb227 0 22015.5107
Rl227 out227 0 10
Vr228 ref228 0 0.595735025
E228 out228 0 ref228 fb228 1e6
R3_228 out228 fb228 100907.132
R4_228 fb228 0 21800.445
Rl228 out228 0 10
Vr229 ref229 0 0.608744522
E229 out229 0 ref229 fb229 1e6
R3_229 out229 fb229 99596.8738
R4_229 fb229 0 21787.0699
Rl229 out229 0 10
Vr230 ref230 0 0.594471628
E230 out230 0 ref230 fb230 1e6
R3_230 out230 fb230 100055.504
R4_230 fb230 0 21781.3561
Rl230 out230 0 10
Vr231 ref231 0 0.598412589
E231 out231 0 ref231 fb231 1e6
R3_231 out231 fb231 99406.203
R4_231 fb231 0 21961.9946
Rl231 out231 0 10
Vr232 ref232 0 0.603694171
E232 out232 0 ref232 fb232 1e6
R3_232 out232 fb232 100652.212
R4_232 fb232 0 22174.1573
Rl232 out232 0 10
Vr233 ref233 0 0.604479765
E233 out233 0 ref233 fb233 1e6
R3_233 out233 fb233 99752.7282
R4_233 fb233 0 22122.4745
Rl233 out233 0 10
Vr234 ref234 0 0.611153065
E234 out234 0 ref234 fb234 1e6
R3_234 out234 fb234 100823.178
R4_234 fb234 0 22069.019
Rl234 out234 0 10
Vr235 ref235 0 0.60183703
E235 out235 0 ref235 fb235 1e6
R3_235 out235 fb235 99755.4311
R4_235 fb235 0 22127.7597
Rl235 out235 0 10
Vr236 ref236 0 0.606435157
E236 out236 0 ref236 fb236 1e6
R3_236 out236 fb236 100001.985
R4_236 fb236 0 21941.2662
Rl236 out236 0 10
Vr237 ref237 0 0.597690237
E237 out237 0 ref237 fb237 1e6
R3_237 out237 fb237 100685.125
R4_237 fb237 0 22180.1704
Rl237 out237 0 10
Vr238 ref238 0 0.605100663
E238 out238 0 ref238 fb238 1e6
R3_238 out238 fb238 100133.115
R4_238 fb238 0 22120.1845
Rl238 out238 0 10
Vr239 ref239 0 0.607088887
E239 out239 0 ref239 fb239 1e6
R3_239 out239 fb239 99076.1549
R4_239 fb239 0 21864.2091
Rl239 out239 0 10
Vr240 ref240 0 0.607687074
E240 out240 0 ref240 fb240 1e6
R3_240 out240 fb240 99214.6355
R4_240 fb240 0 21835.8308
Rl240 out240 0 10
Vr241 ref241 0 0.594773575
E241 out241 0 ref241 fb241 1e6
R3_241 out241 fb241 99052.7573
R4_241 fb241 0 21859.3236
Rl241 out241 0 10
Vr242 ref242 0 0.611987727
E242 out242 0 ref242 fb242 1e6
R3_242 out242 fb242 100646.477
R4_242 fb242 0 22002.2849
Rl242 out242 0 10
Vr243 ref243 0 0.596634023
E243 out243 0 ref243 fb243 1e6
R3_243 out243 fb243 100610.642
R4_243 fb243 0 21970.7423
Rl243 out243 0 10
Vr244 ref244 0 0.589649233
E244 out244 0 ref244 fb244 1e6
R3_244 out244 fb244 100002.133
R4_244 fb244 0 21978.8207
Rl244 out244 0 10
Vr245 ref245 0 0.591195679
E245 out245 0 ref245 fb245 1e6
R3_245 out245 fb245 100883.002
R4_245 fb245 0 21850.1144
Rl245 out245 0 10
Vr246 ref246 0 0.610663535
E246 out246 0 ref246 fb246 1e6
R3_246 out246 fb246 100084.92
R4_246 fb246 0 21895.0914
Rl246 out246 0 10
Vr247 ref247 0 0.589686963
E247 out247 0 ref247 fb247 1e6
R3_247 out247 fb247 100569.147
R4_247 fb247 0 22067.7084
Rl247 out247 0 10
Vr248 ref248 0 0.593130711
E248 out248 0 ref248 fb248 1e6
R3_248 out248 fb248 100366.967
R4_248 fb248 0 21893.1092
Rl248 out248 0 10
Vr249 ref249 0 0.59082192
E249 out249 0 ref249 fb249 1e6
R3_249 out249 fb249 100904.147
R4_249 fb249 0 22145.669
Rl249 out249 0 10
Vr250 ref250 0 0.591250694
E250 out250 0 ref250 fb250 1e6
R3_250 out250 fb250 100570.518
R4_250 fb250 0 22143.1363
Rl250 out250 0 10
Vr251 ref251 0 0.610127071
E251 out251 0 ref251 fb251 1e6
R3_251 out251 fb251 100354.155
R4_251 fb251 0 22016.041
Rl251 out251 0 10
Vr252 ref252 0 0.602481641
E252 out252 0 ref252 fb252 1e6
R3_252 out252 fb252 100735.32
R4_252 fb252 0 22025.1376
Rl252 out252 0 10
Vr253 ref253 0 0.593288465
E253 out253 0 ref253 fb253 1e6
R3_253 out253 fb253 99141.0583
R4_253 fb253 0 22144.275
Rl253 out253 0 10
Vr254 ref254 0 0.592296144
E254 out254 0 ref254 fb254 1e6
R3_254 out254 fb254 99308.7357
R4_254 fb254 0 21959.8851
Rl254 out254 0 10
Vr255 ref255 0 0.607553785
E255 out255 0 ref255 fb255 1e6
R3_255 out255 fb255 99431.2667
R4_255 fb255 0 22006.5749
Rl255 out255 0 10
Vr256 ref256 0 0.609836678
E256 out256 0 ref256 fb256 1e6
R3_256 out256 fb256 100195.082
R4_256 fb256 0 21942.4954
Rl256 out256 0 10
Vr257 ref257 0 0.60430884
E257 out257 0 ref257 fb257 1e6
R3_257 out257 fb257 100568.951
R4_257 fb257 0 21780.7585
Rl257 out257 0 10
Vr258 ref258 0 0.588915087
E258 out258 0 ref258 fb258 1e6
R3_258 out258 fb258 100887.72
R4_258 fb258 0 22127.571
Rl258 out258 0 10
Vr259 ref259 0 0.609494855
E259 out259 0 ref259 fb259 1e6
R3_259 out259 fb259 99648.2461
R4_259 fb259 0 21784.6094
Rl259 out259 0 10
Vr260 ref260 0 0.591795916
E260 out260 0 ref260 fb260 1e6
R3_260 out260 fb260 99304.6918
R4_260 fb260 0 22131.4938
Rl260 out260 0 10
Vr261 ref261 0 0.600492755
E261 out261 0 ref261 fb261 1e6
R3_261 out261 fb261 99197.2228
R4_261 fb261 0 21921.3959
Rl261 out261 0 10
Vr262 ref262 0 0.608856919
E262 out262 0 ref262 fb262 1e6
R3_262 out262 fb262 100416.718
R4_262 fb262 0 22182.9785
Rl262 out262 0 10
Vr263 ref263 0 0.590105752
E263 out263 0 ref263 fb263 1e6
R3_263 out263 fb263 100078.465
R4_263 fb263 0 21807.3171
Rl263 out263 0 10
Vr264 ref264 0 0.610607658
E264 out264 0 ref264 fb264 1e6
R3_264 out264 fb264 100951.471
R4_264 fb264 0 22042.2388
Rl264 out264 0 10
Vr265 ref265 0 0.608643778
E265 out265 0 ref265 fb265 1e6
R3_265 out265 fb265 100013.868
R4_265 fb265 0 22038.7986
Rl265 out265 0 10
Vr266 ref266 0 0.60489982
E266 out266 0 ref266 fb266 1e6
R3_266 out266 fb266 100645.525
R4_266 fb266 0 22142.0731
Rl266 out266 0 10
Vr267 ref267 0 0.611933583
E267 out267 0 ref267 fb267 1e6
R3_267 out267 fb267 99192.035
R4_267 fb267 0 21931.3972
Rl267 out267 0 10
Vr268 ref268 0 0.605062646
E268 out268 0 ref268 fb268 1e6
R3_268 out268 fb268 99814.8733
R4_268 fb268 0 22219.5203
Rl268 out268 0 10
Vr269 ref269 0 0.602111364
E269 out269 0 ref269 fb269 1e6
R3_269 out269 fb269 100726.135
R4_269 fb269 0 22180.1128
Rl269 out269 0 10
Vr270 ref270 0 0.595308643
E270 out270 0 ref270 fb270 1e6
R3_270 out270 fb270 99952.4194
R4_270 fb270 0 22208.2931
Rl270 out270 0 10
Vr271 ref271 0 0.604125048
E271 out271 0 ref271 fb271 1e6
R3_271 out271 fb271 100435.529
R4_271 fb271 0 21918.9817
Rl271 out271 0 10
Vr272 ref272 0 0.604990021
E272 out272 0 ref272 fb272 1e6
R3_272 out272 fb272 100859.303
R4_272 fb272 0 22102.836
Rl272 out272 0 10
Vr273 ref273 0 0.592323409
E273 out273 0 ref273 fb273 1e6
R3_273 out273 fb273 100655.727
R4_273 fb273 0 22044.221
Rl273 out273 0 10
Vr274 ref274 0 0.600481591
E274 out274 0 ref274 fb274 1e6
R3_274 out274 fb274 100206.116
R4_274 fb274 0 21860.6178
Rl274 out274 0 10
Vr275 ref275 0 0.590371708
E275 out275 0 ref275 fb275 1e6
R3_275 out275 fb275 100037.209
R4_275 fb275 0 22082.6721
Rl275 out275 0 10
Vr276 ref276 0 0.598802802
E276 out276 0 ref276 fb276 1e6
R3_276 out276 fb276 100403.704
R4_276 fb276 0 21796.5729
Rl276 out276 0 10
Vr277 ref277 0 0.589667617
E277 out277 0 ref277 fb277 1e6
R3_277 out277 fb277 99608.5349
R4_277 fb277 0 21891.6582
Rl277 out277 0 10
Vr278 ref278 0 0.601621431
E278 out278 0 ref278 fb278 1e6
R3_278 out278 fb278 100577.963
R4_278 fb278 0 21994.343
Rl278 out278 0 10
Vr279 ref279 0 0.598131218
E279 out279 0 ref279 fb279 1e6
R3_279 out279 fb279 99345.6654
R4_279 fb279 0 22141.0532
Rl279 out279 0 10
Vr280 ref280 0 0.604924175
E280 out280 0 ref280 fb280 1e6
R3_280 out280 fb280 99337.8278
R4_280 fb280 0 21984.8299
Rl280 out280 0 10
Vr281 ref281 0 0.592802022
E281 out281 0 ref281 fb281 1e6
R3_281 out281 fb281 99591.4571
R4_281 fb281 0 22049.648
Rl281 out281 0 10
Vr282 ref282 0 0.59185035
E282 out282 0 ref282 fb282 1e6
R3_282 out282 fb282 99507.1424
R4_282 fb282 0 22203.6484
Rl282 out282 0 10
Vr283 ref283 0 0.596821033
E283 out283 0 ref283 fb283 1e6
R3_283 out283 fb283 99308.0659
R4_283 fb283 0 21976.0207
Rl283 out283 0 10
Vr284 ref284 0 0.601895398
E284 out284 0 ref284 fb284 1e6
R3_284 out284 fb284 99319.618
R4_284 fb284 0 22168.2448
Rl284 out284 0 10
Vr285 ref285 0 0.604578426
E285 out285 0 ref285 fb285 1e6
R3_285 out285 fb285 100181.675
R4_285 fb285 0 21862.1815
Rl285 out285 0 10
Vr286 ref286 0 0.596972767
E286 out286 0 ref286 fb286 1e6
R3_286 out286 fb286 100484.931
R4_286 fb286 0 21809.6009
Rl286 out286 0 10
Vr287 ref287 0 0.591288116
E287 out287 0 ref287 fb287 1e6
R3_287 out287 fb287 100777.265
R4_287 fb287 0 21803.1271
Rl287 out287 0 10
Vr288 ref288 0 0.595014118
E288 out288 0 ref288 fb288 1e6
R3_288 out288 fb288 99935.154
R4_288 fb288 0 22083.4069
Rl288 out288 0 10
Vr289 ref289 0 0.59587989
E289 out289 0 ref289 fb289 1e6
R3_289 out289 fb289 99718.163
R4_289 fb289 0 22025.5857
Rl289 out289 0 10
Vr290 ref290 0 0.608845717
E290 out290 0 ref290 fb290 1e6
R3_290 out290 fb290 99801.4604
R4_290 fb290 0 22017.9251
Rl290 out290 0 10
Vr291 ref291 0 0.603090189
E291 out291 0 ref291 fb291 1e6
R3_291 out291 fb291 99954.2414
R4_291 fb291 0 21967.3539
Rl291 out291 0 10
Vr292 ref292 0 0.589860048
E292 out292 0 ref292 fb292 1e6
R3_292 out292 fb292 100834.136
R4_292 fb292 0 21854.9902
Rl292 out292 0 10
Vr293 ref293 0 0.591518754
E293 out293 0 ref293 fb293 1e6
R3_293 out293 fb293 100185.361
R4_293 fb293 0 21802.7679
Rl293 out293 0 10
Vr294 ref294 0 0.599115113
E294 out294 0 ref294 fb294 1e6
R3_294 out294 fb294 100469.332
R4_294 fb294 0 22047.0117
Rl294 out294 0 10
Vr295 ref295 0 0.604780377
E295 out295 0 ref295 fb295 1e6
R3_295 out295 fb295 99715.3147
R4_295 fb295 0 22184.4735
Rl295 out295 0 10
Vr296 ref296 0 0.608388547
E296 out296 0 ref296 fb296 1e6
R3_296 out296 fb296 99809.2986
R4_296 fb296 0 21972.8402
Rl296 out296 0 10
Vr297 ref297 0 0.588529025
E297 out297 0 ref297 fb297 1e6
R3_297 out297 fb297 99325.6145
R4_297 fb297 0 22159.0236
Rl297 out297 0 10
Vr298 ref298 0 0.595453036
E298 out298 0 ref298 fb298 1e6
R3_298 out298 fb298 100511.186
R4_298 fb298 0 21902.4622
Rl298 out298 0 10
Vr299 ref299 0 0.599869671
E299 out299 0 ref299 fb299 1e6
R3_299 out299 fb299 100796.634
R4_299 fb299 0 21820.1058
Rl299 out299 0 10
Vr300 ref300 0 0.607567601
E300 out300 0 ref300 fb300 1e6
R3_300 out300 fb300 99217.7982
R4_300 fb300 0 21871.2072
Rl300 out300 0 10
Vr301 ref301 0 0.609379227
E301 out301 0 ref301 fb301 1e6
R3_301 out301 fb301 99259.1511
R4_301 fb301 0 22146.5988
Rl301 out301 0 10
Vr302 ref302 0 0.592045847
E302 out302 0 ref302 fb302 1e6
R3_302 out302 fb302 100063.103
R4_302 fb302 0 22173.6561
Rl302 out302 0 10
Vr303 ref303 0 0.605497061
E303 out303 0 ref303 fb303 1e6
R3_303 out303 fb303 100325.781
R4_303 fb303 0 21854.7602
Rl303 out303 0 10
Vr304 ref304 0 0.6076777
E304 out304 0 ref304 fb304 1e6
R3_304 out304 fb304 100863.616
R4_304 fb304 0 22134.7575
Rl304 out304 0 10
Vr305 ref305 0 0.594632037
E305 out305 0 ref305 fb305 1e6
R3_305 out305 fb305 99883.3264
R4_305 fb305 0 21998.1482
Rl305 out305 0 10
Vr306 ref306 0 0.592669941
E306 out306 0 ref306 fb306 1e6
R3_306 out306 fb306 99219.6683
R4_306 fb306 0 22010.8267
Rl306 out306 0 10
Vr307 ref307 0 0.60116408
E307 out307 0 ref307 fb307 1e6
R3_307 out307 fb307 100967.774
R4_307 fb307 0 21852.6515
Rl307 out307 0 10
Vr308 ref308 0 0.588559861
E308 out308 0 ref308 fb308 1e6
R3_308 out308 fb308 99989.3407
R4_308 fb308 0 22194.8886
Rl308 out308 0 10
Vr309 ref309 0 0.605142551
E309 out309 0 ref309 fb309 1e6
R3_309 out309 fb309 100546.454
R4_309 fb309 0 22049.8385
Rl309 out309 0 10
Vr310 ref310 0 0.601785694
E310 out310 0 ref310 fb310 1e6
R3_310 out310 fb310 100904.821
R4_310 fb310 0 21991.0221
Rl310 out310 0 10
Vr311 ref311 0 0.594108049
E311 out311 0 ref311 fb311 1e6
R3_311 out311 fb311 99716.127
R4_311 fb311 0 21948.9137
Rl311 out311 0 10
Vr312 ref312 0 0.610100866
E312 out312 0 ref312 fb312 1e6
R3_312 out312 fb312 100736.767
R4_312 fb312 0 21948.9011
Rl312 out312 0 10
Vr313 ref313 0 0.604856831
E313 out313 0 ref313 fb313 1e6
R3_313 out313 fb313 99304.5771
R4_313 fb313 0 21883.8699
Rl313 out313 0 10
Vr314 ref314 0 0.593072358
E314 out314 0 ref314 fb314 1e6
R3_314 out314 fb314 99412.8531
R4_314 fb314 0 21803.3291
Rl314 out314 0 10
Vr315 ref315 0 0.593624911
E315 out315 0 ref315 fb315 1e6
R3_315 out315 fb315 100742.729
R4_315 fb315 0 21941.0958
Rl315 out315 0 10
Vr316 ref316 0 0.591511976
E316 out316 0 ref316 fb316 1e6
R3_316 out316 fb316 100761.665
R4_316 fb316 0 21838.6847
Rl316 out316 0 10
Vr317 ref317 0 0.590926339
E317 out317 0 ref317 fb317 1e6
R3_317 out317 fb317 99700.2946
R4_317 fb317 0 21786.1943
Rl317 out317 0 10
Vr318 ref318 0 0.596239698
E318 out318 0 ref318 fb318 1e6
R3_318 out318 fb318 99723.041
R4_318 fb318 0 21990.1254
Rl318 out318 0 10
Vr319 ref319 0 0.610514109
E319 out319 0 ref319 fb319 1e6
R3_319 out319 fb319 99145.6107
R4_319 fb319 0 21999.5963
Rl319 out319 0 10
Vr320 ref320 0 0.594379804
E320 out320 0 ref320 fb320 1e6
R3_320 out320 fb320 99141.9615
R4_320 fb320 0 21970.5868
Rl320 out320 0 10
Vr321 ref321 0 0.611204129
E321 out321 0 ref321 fb321 1e6
R3_321 out321 fb321 99977.0406
R4_321 fb321 0 21926.1724
Rl321 out321 0 10
Vr322 ref322 0 0.59262417
E322 out322 0 ref322 fb322 1e6
R3_322 out322 fb322 99391.5489
R4_322 fb322 0 22068.3758
Rl322 out322 0 10
Vr323 ref323 0 0.588851267
E323 out323 0 ref323 fb323 1e6
R3_323 out323 fb323 100276.34
R4_323 fb323 0 22100.6899
Rl323 out323 0 10
Vr324 ref324 0 0.608148362
E324 out324 0 ref324 fb324 1e6
R3_324 out324 fb324 99034.5582
R4_324 fb324 0 22150.2837
Rl324 out324 0 10
Vr325 ref325 0 0.603942586
E325 out325 0 ref325 fb325 1e6
R3_325 out325 fb325 100173.423
R4_325 fb325 0 22023.2488
Rl325 out325 0 10
Vr326 ref326 0 0.590761767
E326 out326 0 ref326 fb326 1e6
R3_326 out326 fb326 99901.0664
R4_326 fb326 0 21821.7818
Rl326 out326 0 10
Vr327 ref327 0 0.601527072
E327 out327 0 ref327 fb327 1e6
R3_327 out327 fb327 100834.484
R4_327 fb327 0 21899.5975
Rl327 out327 0 10
Vr328 ref328 0 0.606300604
E328 out328 0 ref328 fb328 1e6
R3_328 out328 fb328 99245.5854
R4_328 fb328 0 21913.162
Rl328 out328 0 10
Vr329 ref329 0 0.593007615
E329 out329 0 ref329 fb329 1e6
R3_329 out329 fb329 100516.214
R4_329 fb329 0 22007.6465
Rl329 out329 0 10
Vr330 ref330 0 0.608154334
E330 out330 0 ref330 fb330 1e6
R3_330 out330 fb330 100682.082
R4_330 fb330 0 21887.3017
Rl330 out330 0 10
Vr331 ref331 0 0.609439341
E331 out331 0 ref331 fb331 1e6
R3_331 out331 fb331 99309.723
R4_331 fb331 0 21920.7672
Rl331 out331 0 10
Vr332 ref332 0 0.59461807
E332 out332 0 ref332 fb332 1e6
R3_332 out332 fb332 99399.0327
R4_332 fb332 0 22075.5125
Rl332 out332 0 10
Vr333 ref333 0 0.595038046
E333 out333 0 ref333 fb333 1e6
R3_333 out333 fb333 100035.789
R4_333 fb333 0 22162.6468
Rl333 out333 0 10
Vr334 ref334 0 0.608325858
E334 out334 0 ref334 fb334 1e6
R3_334 out334 fb334 99551.875
R4_334 fb334 0 21980.3096
Rl334 out334 0 10
Vr335 ref335 0 0.592451199
E335 out335 0 ref335 fb335 1e6
R3_335 out335 fb335 99173.6432
R4_335 fb335 0 22052.2183
Rl335 out335 0 10
Vr336 ref336 0 0.599660437
E336 out336 0 ref336 fb336 1e6
R3_336 out336 fb336 100739.964
R4_336 fb336 0 22072.298
Rl336 out336 0 10
Vr337 ref337 0 0.608252392
E337 out337 0 ref337 fb337 1e6
R3_337 out337 fb337 100517.504
R4_337 fb337 0 22049.9424
Rl337 out337 0 10
Vr338 ref338 0 0.609574191
E338 out338 0 ref338 fb338 1e6
R3_338 out338 fb338 99055.4529
R4_338 fb338 0 22170.677
Rl338 out338 0 10
Vr339 ref339 0 0.589870757
E339 out339 0 ref339 fb339 1e6
R3_339 out339 fb339 100597.531
R4_339 fb339 0 21946.5291
Rl339 out339 0 10
Vr340 ref340 0 0.588733489
E340 out340 0 ref340 fb340 1e6
R3_340 out340 fb340 100696.267
R4_340 fb340 0 22198.8721
Rl340 out340 0 10
Vr341 ref341 0 0.608071115
E341 out341 0 ref341 fb341 1e6
R3_341 out341 fb341 99974.284
R4_341 fb341 0 21784.8742
Rl341 out341 0 10
Vr342 ref342 0 0.590396467
E342 out342 0 ref342 fb342 1e6
R3_342 out342 fb342 99082.9827
R4_342 fb342 0 21980.6226
Rl342 out342 0 10
Vr343 ref343 0 0.591124361
E343 out343 0 ref343 fb343 1e6
R3_343 out343 fb343 100159.868
R4_343 fb343 0 22113.2124
Rl343 out343 0 10
Vr344 ref344 0 0.607581871
E344 out344 0 ref344 fb344 1e6
R3_344 out344 fb344 99249.114
R4_344 fb344 0 22005.6737
Rl344 out344 0 10
Vr345 ref345 0 0.59971504
E345 out345 0 ref345 fb345 1e6
R3_345 out345 fb345 99699.03
R4_345 fb345 0 22090.2746
Rl345 out345 0 10
Vr346 ref346 0 0.606093937
E346 out346 0 ref346 fb346 1e6
R3_346 out346 fb346 100359.361
R4_346 fb346 0 21986.5624
Rl346 out346 0 10
Vr347 ref347 0 0.593923587
E347 out347 0 ref347 fb347 1e6
R3_347 out347 fb347 100718.474
R4_347 fb347 0 21844.2639
Rl347 out347 0 10
Vr348 ref348 0 0.598992772
E348 out348 0 ref348 fb348 1e6
R3_348 out348 fb348 100203.517
R4_348 fb348 0 21995.61
Rl348 out348 0 10
Vr349 ref349 0 0.611313985
E349 out349 0 ref349 fb349 1e6
R3_349 out349 fb349 100264.576
R4_349 fb349 0 21880.0007
Rl349 out349 0 10
Vr350 ref350 0 0.595212339
E350 out350 0 ref350 fb350 1e6
R3_350 out350 fb350 99074.5307
R4_350 fb350 0 21804.0658
Rl350 out350 0 10
Vr351 ref351 0 0.61196132
E351 out351 0 ref351 fb351 1e6
R3_351 out351 fb351 100769.379
R4_351 fb351 0 22219.8363
Rl351 out351 0 10
Vr352 ref352 0 0.599345649
E352 out352 0 ref352 fb352 1e6
R3_352 out352 fb352 100477.325
R4_352 fb352 0 22034.945
Rl352 out352 0 10
Vr353 ref353 0 0.590382073
E353 out353 0 ref353 fb353 1e6
R3_353 out353 fb353 100772.423
R4_353 fb353 0 22044.6557
Rl353 out353 0 10
Vr354 ref354 0 0.597723585
E354 out354 0 ref354 fb354 1e6
R3_354 out354 fb354 99086.6867
R4_354 fb354 0 21937.1954
Rl354 out354 0 10
Vr355 ref355 0 0.603024438
E355 out355 0 ref355 fb355 1e6
R3_355 out355 fb355 99967.0042
R4_355 fb355 0 21988.1846
Rl355 out355 0 10
Vr356 ref356 0 0.592987825
E356 out356 0 ref356 fb356 1e6
R3_356 out356 fb356 100616.911
R4_356 fb356 0 21938.9813
Rl356 out356 0 10
Vr357 ref357 0 0.591630493
E357 out357 0 ref357 fb357 1e6
R3_357 out357 fb357 100197.835
R4_357 fb357 0 21806.2345
Rl357 out357 0 10
Vr358 ref358 0 0.608307292
E358 out358 0 ref358 fb358 1e6
R3_358 out358 fb358 100358.888
R4_358 fb358 0 21784.5448
Rl358 out358 0 10
Vr359 ref359 0 0.601802655
E359 out359 0 ref359 fb359 1e6
R3_359 out359 fb359 100279.97
R4_359 fb359 0 22030.7823
Rl359 out359 0 10
Vr360 ref360 0 0.589462542
E360 out360 0 ref360 fb360 1e6
R3_360 out360 fb360 100596.279
R4_360 fb360 0 21802.2918
Rl360 out360 0 10
Vr361 ref361 0 0.604006457
E361 out361 0 ref361 fb361 1e6
R3_361 out361 fb361 100091.582
R4_361 fb361 0 22002.8127
Rl361 out361 0 10
Vr362 ref362 0 0.603030742
E362 out362 0 ref362 fb362 1e6
R3_362 out362 fb362 99897.4955
R4_362 fb362 0 21870.4739
Rl362 out362 0 10
Vr363 ref363 0 0.595182146
E363 out363 0 ref363 fb363 1e6
R3_363 out363 fb363 100924.528
R4_363 fb363 0 21840.7061
Rl363 out363 0 10
Vr364 ref364 0 0.594285424
E364 out364 0 ref364 fb364 1e6
R3_364 out364 fb364 100215.628
R4_364 fb364 0 21922.2158
Rl364 out364 0 10
Vr365 ref365 0 0.597521123
E365 out365 0 ref365 fb365 1e6
R3_365 out365 fb365 99089.4156
R4_365 fb365 0 22037.7495
Rl365 out365 0 10
Vr366 ref366 0 0.588977082
E366 out366 0 ref366 fb366 1e6
R3_366 out366 fb366 99270.7442
R4_366 fb366 0 21799.4802
Rl366 out366 0 10
Vr367 ref367 0 0.590597062
E367 out367 0 ref367 fb367 1e6
R3_367 out367 fb367 100111.672
R4_367 fb367 0 21908.8328
Rl367 out367 0 10
Vr368 ref368 0 0.608276192
E368 out368 0 ref368 fb368 1e6
R3_368 out368 fb368 99132.7036
R4_368 fb368 0 21818.0017
Rl368 out368 0 10
Vr369 ref369 0 0.590865812
E369 out369 0 ref369 fb369 1e6
R3_369 out369 fb369 99389.0924
R4_369 fb369 0 22017.8099
Rl369 out369 0 10
Vr370 ref370 0 0.598153728
E370 out370 0 ref370 fb370 1e6
R3_370 out370 fb370 99409.7014
R4_370 fb370 0 22168.4473
Rl370 out370 0 10
Vr371 ref371 0 0.602310764
E371 out371 0 ref371 fb371 1e6
R3_371 out371 fb371 99231.2851
R4_371 fb371 0 21967.3676
Rl371 out371 0 10
Vr372 ref372 0 0.596324255
E372 out372 0 ref372 fb372 1e6
R3_372 out372 fb372 100916.709
R4_372 fb372 0 21848.297
Rl372 out372 0 10
Vr373 ref373 0 0.599910521
E373 out373 0 ref373 fb373 1e6
R3_373 out373 fb373 100008.724
R4_373 fb373 0 21854.3574
Rl373 out373 0 10
Vr374 ref374 0 0.599873025
E374 out374 0 ref374 fb374 1e6
R3_374 out374 fb374 99331.2349
R4_374 fb374 0 22037.2019
Rl374 out374 0 10
Vr375 ref375 0 0.609579825
E375 out375 0 ref375 fb375 1e6
R3_375 out375 fb375 100075.983
R4_375 fb375 0 21866.0281
Rl375 out375 0 10
Vr376 ref376 0 0.60248514
E376 out376 0 ref376 fb376 1e6
R3_376 out376 fb376 99156.0165
R4_376 fb376 0 22215.3985
Rl376 out376 0 10
Vr377 ref377 0 0.609800858
E377 out377 0 ref377 fb377 1e6
R3_377 out377 fb377 100859.122
R4_377 fb377 0 22003.9809
Rl377 out377 0 10
Vr378 ref378 0 0.593487523
E378 out378 0 ref378 fb378 1e6
R3_378 out378 fb378 99484.0194
R4_378 fb378 0 21887.0771
Rl378 out378 0 10
Vr379 ref379 0 0.598318302
E379 out379 0 ref379 fb379 1e6
R3_379 out379 fb379 100610.228
R4_379 fb379 0 22142.3346
Rl379 out379 0 10
Vr380 ref380 0 0.611501551
E380 out380 0 ref380 fb380 1e6
R3_380 out380 fb380 99681.0444
R4_380 fb380 0 22190.2822
Rl380 out380 0 10
Vr381 ref381 0 0.602531644
E381 out381 0 ref381 fb381 1e6
R3_381 out381 fb381 99304.4095
R4_381 fb381 0 22136.9314
Rl381 out381 0 10
Vr382 ref382 0 0.589193502
E382 out382 0 ref382 fb382 1e6
R3_382 out382 fb382 100857.754
R4_382 fb382 0 21955.4896
Rl382 out382 0 10
Vr383 ref383 0 0.606255582
E383 out383 0 ref383 fb383 1e6
R3_383 out383 fb383 100688.336
R4_383 fb383 0 22003.126
Rl383 out383 0 10
Vr384 ref384 0 0.59563575
E384 out384 0 ref384 fb384 1e6
R3_384 out384 fb384 100887.677
R4_384 fb384 0 22036.3601
Rl384 out384 0 10
Vr385 ref385 0 0.610291654
E385 out385 0 ref385 fb385 1e6
R3_385 out385 fb385 99082.1465
R4_385 fb385 0 21902.9286
Rl385 out385 0 10
Vr386 ref386 0 0.591196086
E386 out386 0 ref386 fb386 1e6
R3_386 out386 fb386 100281.138
R4_386 fb386 0 21827.8422
Rl386 out386 0 10
Vr387 ref387 0 0.605327094
E387 out387 0 ref387 fb387 1e6
R3_387 out387 fb387 99740.6077
R4_387 fb387 0 21883.441
Rl387 out387 0 10
Vr388 ref388 0 0.606839344
E388 out388 0 ref388 fb388 1e6
R3_388 out388 fb388 99090.3019
R4_388 fb388 0 22049.6211
Rl388 out388 0 10
Vr389 ref389 0 0.589206373
E389 out389 0 ref389 fb389 1e6
R3_389 out389 fb389 99108.2538
R4_389 fb389 0 21988.5573
Rl389 out389 0 10
Vr390 ref390 0 0.591542926
E390 out390 0 ref390 fb390 1e6
R3_390 out390 fb390 100552.762
R4_390 fb390 0 22123.0284
Rl390 out390 0 10
Vr391 ref391 0 0.588671822
E391 out391 0 ref391 fb391 1e6
R3_391 out391 fb391 99805.1389
R4_391 fb391 0 22094.8058
Rl391 out391 0 10
Vr392 ref392 0 0.5951104
E392 out392 0 ref392 fb392 1e6
R3_392 out392 fb392 100843.704
R4_392 fb392 0 22172.1083
Rl392 out392 0 10
Vr393 ref393 0 0.602040463
E393 out393 0 ref393 fb393 1e6
R3_393 out393 fb393 100065.778
R4_393 fb393 0 21811.0542
Rl393 out393 0 10
Vr394 ref394 0 0.600777611
E394 out394 0 ref394 fb394 1e6
R3_394 out394 fb394 99477.4076
R4_394 fb394 0 22193.4474
Rl394 out394 0 10
Vr395 ref395 0 0.604421003
E395 out395 0 ref395 fb395 1e6
R3_395 out395 fb395 100284.275
R4_395 fb395 0 22040.5852
Rl395 out395 0 10
Vr396 ref396 0 0.609791273
E396 out396 0 ref396 fb396 1e6
R3_396 out396 fb396 99965.5121
R4_396 fb396 0 22149.6347
Rl396 out396 0 10
Vr397 ref397 0 0.592994265
E397 out397 0 ref397 fb397 1e6
R3_397 out397 fb397 100159.063
R4_397 fb397 0 22142.9392
Rl397 out397 0 10
Vr398 ref398 0 0.597301337
E398 out398 0 ref398 fb398 1e6
R3_398 out398 fb398 99945.1073
R4_398 fb398 0 22039.2298
Rl398 out398 0 10
Vr399 ref399 0 0.610977144
E399 out399 0 ref399 fb399 1e6
R3_399 out399 fb399 99416.282
R4_399 fb399 0 21805.9578
Rl399 out399 0 10
Vr400 ref400 0 0.591490027
E400 out400 0 ref400 fb400 1e6
R3_400 out400 fb400 100705.901
R4_400 fb400 0 22029.353
Rl400 out400 0 10
Vr401 ref401 0 0.599181948
E401 out401 0 ref401 fb401 1e6
R3_401 out401 fb401 100914.18
R4_401 fb401 0 22150.2267
Rl401 out401 0 10
Vr402 ref402 0 0.596398887
E402 out402 0 ref402 fb402 1e6
R3_402 out402 fb402 99159.9785
R4_402 fb402 0 21971.403
Rl402 out402 0 10
Vr403 ref403 0 0.609004892
E403 out403 0 ref403 fb403 1e6
R3_403 out403 fb403 99052.1649
R4_403 fb403 0 21812.3624
Rl403 out403 0 10
Vr404 ref404 0 0.601276191
E404 out404 0 ref404 fb404 1e6
R3_404 out404 fb404 100604.862
R4_404 fb404 0 21818.9044
Rl404 out404 0 10
Vr405 ref405 0 0.607672743
E405 out405 0 ref405 fb405 1e6
R3_405 out405 fb405 99501.9974
R4_405 fb405 0 21981.5935
Rl405 out405 0 10
Vr406 ref406 0 0.594405554
E406 out406 0 ref406 fb406 1e6
R3_406 out406 fb406 100685.855
R4_406 fb406 0 22183.0811
Rl406 out406 0 10
Vr407 ref407 0 0.592688147
E407 out407 0 ref407 fb407 1e6
R3_407 out407 fb407 99977.8592
R4_407 fb407 0 21806.0314
Rl407 out407 0 10
Vr408 ref408 0 0.596753582
E408 out408 0 ref408 fb408 1e6
R3_408 out408 fb408 99080.8543
R4_408 fb408 0 22176.3922
Rl408 out408 0 10
Vr409 ref409 0 0.59552957
E409 out409 0 ref409 fb409 1e6
R3_409 out409 fb409 100419.465
R4_409 fb409 0 22053.4741
Rl409 out409 0 10
Vr410 ref410 0 0.603437065
E410 out410 0 ref410 fb410 1e6
R3_410 out410 fb410 99044.8646
R4_410 fb410 0 22093.9523
Rl410 out410 0 10
Vr411 ref411 0 0.598202242
E411 out411 0 ref411 fb411 1e6
R3_411 out411 fb411 99515.5601
R4_411 fb411 0 21987.1145
Rl411 out411 0 10
Vr412 ref412 0 0.5908511
E412 out412 0 ref412 fb412 1e6
R3_412 out412 fb412 100129.937
R4_412 fb412 0 21999.4518
Rl412 out412 0 10
Vr413 ref413 0 0.604405259
E413 out413 0 ref413 fb413 1e6
R3_413 out413 fb413 99910.9276
R4_413 fb413 0 22173.05
Rl413 out413 0 10
Vr414 ref414 0 0.588378989
E414 out414 0 ref414 fb414 1e6
R3_414 out414 fb414 100927.022
R4_414 fb414 0 21922.732
Rl414 out414 0 10
Vr415 ref415 0 0.599765424
E415 out415 0 ref415 fb415 1e6
R3_415 out415 fb415 100480.735
R4_415 fb415 0 22129.2109
Rl415 out415 0 10
Vr416 ref416 0 0.592727719
E416 out416 0 ref416 fb416 1e6
R3_416 out416 fb416 100092.002
R4_416 fb416 0 22126.8988
Rl416 out416 0 10
Vr417 ref417 0 0.603753457
E417 out417 0 ref417 fb417 1e6
R3_417 out417 fb417 100250.686
R4_417 fb417 0 21984.1142
Rl417 out417 0 10
Vr418 ref418 0 0.5978725
E418 out418 0 ref418 fb418 1e6
R3_418 out418 fb418 99251.7518
R4_418 fb418 0 22035.3283
Rl418 out418 0 10
Vr419 ref419 0 0.594837825
E419 out419 0 ref419 fb419 1e6
R3_419 out419 fb419 100874.034
R4_419 fb419 0 22195.8683
Rl419 out419 0 10
Vr420 ref420 0 0.602419408
E420 out420 0 ref420 fb420 1e6
R3_420 out420 fb420 100574.104
R4_420 fb420 0 22112.6149
Rl420 out420 0 10
Vr421 ref421 0 0.59119489
E421 out421 0 ref421 fb421 1e6
R3_421 out421 fb421 100263.942
R4_421 fb421 0 21926.6724
Rl421 out421 0 10
Vr422 ref422 0 0.594168899
E422 out422 0 ref422 fb422 1e6
R3_422 out422 fb422 99225.7166
R4_422 fb422 0 22109.6523
Rl422 out422 0 10
Vr423 ref423 0 0.591298065
E423 out423 0 ref423 fb423 1e6
R3_423 out423 fb423 100502.212
R4_423 fb423 0 22012.7332
Rl423 out423 0 10
Vr424 ref424 0 0.598464996
E424 out424 0 ref424 fb424 1e6
R3_424 out424 fb424 100297.818
R4_424 fb424 0 22162.2775
Rl424 out424 0 10
Vr425 ref425 0 0.588894318
E425 out425 0 ref425 fb425 1e6
R3_425 out425 fb425 99619.5867
R4_425 fb425 0 22012.212
Rl425 out425 0 10
Vr426 ref426 0 0.60622443
E426 out426 0 ref426 fb426 1e6
R3_426 out426 fb426 99746.3206
R4_426 fb426 0 22012.5851
Rl426 out426 0 10
Vr427 ref427 0 0.588458682
E427 out427 0 ref427 fb427 1e6
R3_427 out427 fb427 99224.2036
R4_427 fb427 0 21863.9957
Rl427 out427 0 10
Vr428 ref428 0 0.600633762
E428 out428 0 ref428 fb428 1e6
R3_428 out428 fb428 100064.352
R4_428 fb428 0 22007.4077
Rl428 out428 0 10
Vr429 ref429 0 0.606545534
E429 out429 0 ref429 fb429 1e6
R3_429 out429 fb429 100412.106
R4_429 fb429 0 21985.6812
Rl429 out429 0 10
Vr430 ref430 0 0.593224745
E430 out430 0 ref430 fb430 1e6
R3_430 out430 fb430 99887.0892
R4_430 fb430 0 21955.7497
Rl430 out430 0 10
Vr431 ref431 0 0.607004956
E431 out431 0 ref431 fb431 1e6
R3_431 out431 fb431 99135.3615
R4_431 fb431 0 21811.4578
Rl431 out431 0 10
Vr432 ref432 0 0.609148873
E432 out432 0 ref432 fb432 1e6
R3_432 out432 fb432 100331.317
R4_432 fb432 0 21781.8817
Rl432 out432 0 10
Vr433 ref433 0 0.603649877
E433 out433 0 ref433 fb433 1e6
R3_433 out433 fb433 100367.458
R4_433 fb433 0 22071.1245
Rl433 out433 0 10
Vr434 ref434 0 0.589560147
E434 out434 0 ref434 fb434 1e6
R3_434 out434 fb434 99746.713
R4_434 fb434 0 22206.2352
Rl434 out434 0 10
Vr435 ref435 0 0.588608924
E435 out435 0 ref435 fb435 1e6
R3_435 out435 fb435 100572.089
R4_435 fb435 0 22089.9268
Rl435 out435 0 10
Vr436 ref436 0 0.588509533
E436 out436 0 ref436 fb436 1e6
R3_436 out436 fb436 100458.691
R4_436 fb436 0 21928.6758
Rl436 out436 0 10
Vr437 ref437 0 0.591818225
E437 out437 0 ref437 fb437 1e6
R3_437 out437 fb437 100134.16
R4_437 fb437 0 21992.0422
Rl437 out437 0 10
Vr438 ref438 0 0.598677263
E438 out438 0 ref438 fb438 1e6
R3_438 out438 fb438 100843.527
R4_438 fb438 0 22082.6194
Rl438 out438 0 10
Vr439 ref439 0 0.610237904
E439 out439 0 ref439 fb439 1e6
R3_439 out439 fb439 99001.3088
R4_439 fb439 0 22160.3281
Rl439 out439 0 10
Vr440 ref440 0 0.600207473
E440 out440 0 ref440 fb440 1e6
R3_440 out440 fb440 100376.333
R4_440 fb440 0 22099.2622
Rl440 out440 0 10
Vr441 ref441 0 0.593226308
E441 out441 0 ref441 fb441 1e6
R3_441 out441 fb441 99681.2272
R4_441 fb441 0 21820.5583
Rl441 out441 0 10
Vr442 ref442 0 0.594332288
E442 out442 0 ref442 fb442 1e6
R3_442 out442 fb442 99149.3653
R4_442 fb442 0 22155.758
Rl442 out442 0 10
Vr443 ref443 0 0.607931975
E443 out443 0 ref443 fb443 1e6
R3_443 out443 fb443 100945.22
R4_443 fb443 0 22129.3329
Rl443 out443 0 10
Vr444 ref444 0 0.609861466
E444 out444 0 ref444 fb444 1e6
R3_444 out444 fb444 100448.478
R4_444 fb444 0 21785.1259
Rl444 out444 0 10
Vr445 ref445 0 0.60447849
E445 out445 0 ref445 fb445 1e6
R3_445 out445 fb445 100245.591
R4_445 fb445 0 22052.0881
Rl445 out445 0 10
Vr446 ref446 0 0.591320884
E446 out446 0 ref446 fb446 1e6
R3_446 out446 fb446 100627.953
R4_446 fb446 0 22017.3504
Rl446 out446 0 10
Vr447 ref447 0 0.594395783
E447 out447 0 ref447 fb447 1e6
R3_447 out447 fb447 100051.989
R4_447 fb447 0 22102.9991
Rl447 out447 0 10
Vr448 ref448 0 0.592090376
E448 out448 0 ref448 fb448 1e6
R3_448 out448 fb448 99970.6391
R4_448 fb448 0 21821.7376
Rl448 out448 0 10
Vr449 ref449 0 0.606511864
E449 out449 0 ref449 fb449 1e6
R3_449 out449 fb449 100240.835
R4_449 fb449 0 22052.7325
Rl449 out449 0 10
Vr450 ref450 0 0.598738623
E450 out450 0 ref450 fb450 1e6
R3_450 out450 fb450 99252.31
R4_450 fb450 0 22195.8007
Rl450 out450 0 10
Vr451 ref451 0 0.595553992
E451 out451 0 ref451 fb451 1e6
R3_451 out451 fb451 99888.2113
R4_451 fb451 0 21804.6651
Rl451 out451 0 10
Vr452 ref452 0 0.597752506
E452 out452 0 ref452 fb452 1e6
R3_452 out452 fb452 99045.7272
R4_452 fb452 0 21929.6943
Rl452 out452 0 10
Vr453 ref453 0 0.605306341
E453 out453 0 ref453 fb453 1e6
R3_453 out453 fb453 99328.6397
R4_453 fb453 0 22093.7241
Rl453 out453 0 10
Vr454 ref454 0 0.609401585
E454 out454 0 ref454 fb454 1e6
R3_454 out454 fb454 99647.14
R4_454 fb454 0 21956.6114
Rl454 out454 0 10
Vr455 ref455 0 0.609417545
E455 out455 0 ref455 fb455 1e6
R3_455 out455 fb455 99126.4598
R4_455 fb455 0 22054.5973
Rl455 out455 0 10
Vr456 ref456 0 0.60890095
E456 out456 0 ref456 fb456 1e6
R3_456 out456 fb456 99895.7928
R4_456 fb456 0 21982.8864
Rl456 out456 0 10
Vr457 ref457 0 0.601603015
E457 out457 0 ref457 fb457 1e6
R3_457 out457 fb457 99344.223
R4_457 fb457 0 22062.4601
Rl457 out457 0 10
Vr458 ref458 0 0.604446481
E458 out458 0 ref458 fb458 1e6
R3_458 out458 fb458 100727.946
R4_458 fb458 0 22183.9254
Rl458 out458 0 10
Vr459 ref459 0 0.5932618
E459 out459 0 ref459 fb459 1e6
R3_459 out459 fb459 99787.1063
R4_459 fb459 0 21781.5922
Rl459 out459 0 10
Vr460 ref460 0 0.58907878
E460 out460 0 ref460 fb460 1e6
R3_460 out460 fb460 99492.9994
R4_460 fb460 0 21797.2201
Rl460 out460 0 10
Vr461 ref461 0 0.599365174
E461 out461 0 ref461 fb461 1e6
R3_461 out461 fb461 99612.9296
R4_461 fb461 0 22120.5465
Rl461 out461 0 10
Vr462 ref462 0 0.59877147
E462 out462 0 ref462 fb462 1e6
R3_462 out462 fb462 100093.936
R4_462 fb462 0 21792.3313
Rl462 out462 0 10
Vr463 ref463 0 0.589453883
E463 out463 0 ref463 fb463 1e6
R3_463 out463 fb463 100055.359
R4_463 fb463 0 21907.3359
Rl463 out463 0 10
Vr464 ref464 0 0.592605687
E464 out464 0 ref464 fb464 1e6
R3_464 out464 fb464 99061.9442
R4_464 fb464 0 22055.1382
Rl464 out464 0 10
Vr465 ref465 0 0.595103111
E465 out465 0 ref465 fb465 1e6
R3_465 out465 fb465 99833.7186
R4_465 fb465 0 21815.2343
Rl465 out465 0 10
Vr466 ref466 0 0.591741847
E466 out466 0 ref466 fb466 1e6
R3_466 out466 fb466 99051.4751
R4_466 fb466 0 22085.6142
Rl466 out466 0 10
Vr467 ref467 0 0.593452111
E467 out467 0 ref467 fb467 1e6
R3_467 out467 fb467 99025.7323
R4_467 fb467 0 22030.6568
Rl467 out467 0 10
Vr468 ref468 0 0.598509944
E468 out468 0 ref468 fb468 1e6
R3_468 out468 fb468 99940.0559
R4_468 fb468 0 22186.1606
Rl468 out468 0 10
Vr469 ref469 0 0.599829774
E469 out469 0 ref469 fb469 1e6
R3_469 out469 fb469 99010.4213
R4_469 fb469 0 22025.6936
Rl469 out469 0 10
Vr470 ref470 0 0.600286593
E470 out470 0 ref470 fb470 1e6
R3_470 out470 fb470 100935.324
R4_470 fb470 0 22176.7404
Rl470 out470 0 10
Vr471 ref471 0 0.59517749
E471 out471 0 ref471 fb471 1e6
R3_471 out471 fb471 99522.0399
R4_471 fb471 0 22052.0262
Rl471 out471 0 10
Vr472 ref472 0 0.595034405
E472 out472 0 ref472 fb472 1e6
R3_472 out472 fb472 99786.2181
R4_472 fb472 0 21801.3578
Rl472 out472 0 10
Vr473 ref473 0 0.602994734
E473 out473 0 ref473 fb473 1e6
R3_473 out473 fb473 100822.024
R4_473 fb473 0 22194.8892
Rl473 out473 0 10
Vr474 ref474 0 0.595657204
E474 out474 0 ref474 fb474 1e6
R3_474 out474 fb474 99525.2583
R4_474 fb474 0 22065.3917
Rl474 out474 0 10
Vr475 ref475 0 0.592963615
E475 out475 0 ref475 fb475 1e6
R3_475 out475 fb475 100638.049
R4_475 fb475 0 21821.6437
Rl475 out475 0 10
Vr476 ref476 0 0.605207294
E476 out476 0 ref476 fb476 1e6
R3_476 out476 fb476 100765.729
R4_476 fb476 0 21863.4218
Rl476 out476 0 10
Vr477 ref477 0 0.601366134
E477 out477 0 ref477 fb477 1e6
R3_477 out477 fb477 100862.77
R4_477 fb477 0 22117.9628
Rl477 out477 0 10
Vr478 ref478 0 0.596794296
E478 out478 0 ref478 fb478 1e6
R3_478 out478 fb478 100881.407
R4_478 fb478 0 21823.7651
Rl478 out478 0 10
Vr479 ref479 0 0.596607865
E479 out479 0 ref479 fb479 1e6
R3_479 out479 fb479 99534.9206
R4_479 fb479 0 21792.3836
Rl479 out479 0 10
Vr480 ref480 0 0.601191427
E480 out480 0 ref480 fb480 1e6
R3_480 out480 fb480 99711.129
R4_480 fb480 0 21981.2733
Rl480 out480 0 10
Vr481 ref481 0 0.597761223
E481 out481 0 ref481 fb481 1e6
R3_481 out481 fb481 99439.2176
R4_481 fb481 0 22084.2194
Rl481 out481 0 10
Vr482 ref482 0 0.609906467
E482 out482 0 ref482 fb482 1e6
R3_482 out482 fb482 100951.74
R4_482 fb482 0 21828.1483
Rl482 out482 0 10
Vr483 ref483 0 0.609917425
E483 out483 0 ref483 fb483 1e6
R3_483 out483 fb483 99403.6172
R4_483 fb483 0 22207.0958
Rl483 out483 0 10
Vr484 ref484 0 0.594593343
E484 out484 0 ref484 fb484 1e6
R3_484 out484 fb484 100358.936
R4_484 fb484 0 22206.5358
Rl484 out484 0 10
Vr485 ref485 0 0.597265033
E485 out485 0 ref485 fb485 1e6
R3_485 out485 fb485 99654.7237
R4_485 fb485 0 21927.7943
Rl485 out485 0 10
Vr486 ref486 0 0.610320846
E486 out486 0 ref486 fb486 1e6
R3_486 out486 fb486 100322.313
R4_486 fb486 0 21938.5325
Rl486 out486 0 10
Vr487 ref487 0 0.592744904
E487 out487 0 ref487 fb487 1e6
R3_487 out487 fb487 99358.8519
R4_487 fb487 0 22097.1127
Rl487 out487 0 10
Vr488 ref488 0 0.60801243
E488 out488 0 ref488 fb488 1e6
R3_488 out488 fb488 100882.969
R4_488 fb488 0 22029.2811
Rl488 out488 0 10
Vr489 ref489 0 0.594828225
E489 out489 0 ref489 fb489 1e6
R3_489 out489 fb489 100413.342
R4_489 fb489 0 21854.5999
Rl489 out489 0 10
Vr490 ref490 0 0.609908604
E490 out490 0 ref490 fb490 1e6
R3_490 out490 fb490 99489.3162
R4_490 fb490 0 22081.4601
Rl490 out490 0 10
Vr491 ref491 0 0.58840203
E491 out491 0 ref491 fb491 1e6
R3_491 out491 fb491 99202.7367
R4_491 fb491 0 22009.0509
Rl491 out491 0 10
Vr492 ref492 0 0.594255987
E492 out492 0 ref492 fb492 1e6
R3_492 out492 fb492 100163.926
R4_492 fb492 0 22007.5514
Rl492 out492 0 10
Vr493 ref493 0 0.593157227
E493 out493 0 ref493 fb493 1e6
R3_493 out493 fb493 100689.636
R4_493 fb493 0 21941.4954
Rl493 out493 0 10
Vr494 ref494 0 0.605811241
E494 out494 0 ref494 fb494 1e6
R3_494 out494 fb494 99112.9675
R4_494 fb494 0 21984.4641
Rl494 out494 0 10
Vr495 ref495 0 0.597847704
E495 out495 0 ref495 fb495 1e6
R3_495 out495 fb495 99543.7523
R4_495 fb495 0 22161.041
Rl495 out495 0 10
Vr496 ref496 0 0.600793852
E496 out496 0 ref496 fb496 1e6
R3_496 out496 fb496 99945.5065
R4_496 fb496 0 22060.3277
Rl496 out496 0 10
Vr497 ref497 0 0.597309208
E497 out497 0 ref497 fb497 1e6
R3_497 out497 fb497 100812.969
R4_497 fb497 0 22099.495
Rl497 out497 0 10
Vr498 ref498 0 0.607478069
E498 out498 0 ref498 fb498 1e6
R3_498 out498 fb498 100202.189
R4_498 fb498 0 22049.1638
Rl498 out498 0 10
Vr499 ref499 0 0.591175828
E499 out499 0 ref499 fb499 1e6
R3_499 out499 fb499 99359.5981
R4_499 fb499 0 22013.079
Rl499 out499 0 10
Vr500 ref500 0 0.595565063
E500 out500 0 ref500 fb500 1e6
R3_500 out500 fb500 100121.823
R4_500 fb500 0 22173.5222
Rl500 out500 0 10
Vr501 ref501 0 0.597071187
E501 out501 0 ref501 fb501 1e6
R3_501 out501 fb501 100895.187
R4_501 fb501 0 22157.6036
Rl501 out501 0 10
Vr502 ref502 0 0.608528908
E502 out502 0 ref502 fb502 1e6
R3_502 out502 fb502 99730.5869
R4_502 fb502 0 21918.9722
Rl502 out502 0 10
Vr503 ref503 0 0.607613047
E503 out503 0 ref503 fb503 1e6
R3_503 out503 fb503 100221.417
R4_503 fb503 0 22163.3558
Rl503 out503 0 10
Vr504 ref504 0 0.599857171
E504 out504 0 ref504 fb504 1e6
R3_504 out504 fb504 100091.146
R4_504 fb504 0 22091.3159
Rl504 out504 0 10
Vr505 ref505 0 0.598994037
E505 out505 0 ref505 fb505 1e6
R3_505 out505 fb505 99547.9659
R4_505 fb505 0 22203.8217
Rl505 out505 0 10
Vr506 ref506 0 0.611320123
E506 out506 0 ref506 fb506 1e6
R3_506 out506 fb506 100494.094
R4_506 fb506 0 21883.6399
Rl506 out506 0 10
Vr507 ref507 0 0.589581705
E507 out507 0 ref507 fb507 1e6
R3_507 out507 fb507 99469.5336
R4_507 fb507 0 22190.8718
Rl507 out507 0 10
Vr508 ref508 0 0.591403736
E508 out508 0 ref508 fb508 1e6
R3_508 out508 fb508 100054.925
R4_508 fb508 0 21803.5204
Rl508 out508 0 10
Vr509 ref509 0 0.60764378
E509 out509 0 ref509 fb509 1e6
R3_509 out509 fb509 100477.713
R4_509 fb509 0 21858.4768
Rl509 out509 0 10
Vr510 ref510 0 0.606628849
E510 out510 0 ref510 fb510 1e6
R3_510 out510 fb510 100459.942
R4_510 fb510 0 22046.0736
Rl510 out510 0 10
Vr511 ref511 0 0.600603533
E511 out511 0 ref511 fb511 1e6
R3_511 out511 fb511 100514.157
R4_511 fb511 0 21935.0819
Rl511 out511 0 10
Vr512 ref512 0 0.593000124
E512 out512 0 ref512 fb512 1e6
R3_512 out512 fb512 99662.2353
R4_512 fb512 0 22025.4601
Rl512 out512 0 10
Vr513 ref513 0 0.601575948
E513 out513 0 ref513 fb513 1e6
R3_513 out513 fb513 99822.3863
R4_513 fb513 0 21788.9022
Rl513 out513 0 10
Vr514 ref514 0 0.603382521
E514 out514 0 ref514 fb514 1e6
R3_514 out514 fb514 99135.6308
R4_514 fb514 0 21984.0346
Rl514 out514 0 10
Vr515 ref515 0 0.605395771
E515 out515 0 ref515 fb515 1e6
R3_515 out515 fb515 100264.098
R4_515 fb515 0 22014.7956
Rl515 out515 0 10
Vr516 ref516 0 0.605477272
E516 out516 0 ref516 fb516 1e6
R3_516 out516 fb516 99340.3759
R4_516 fb516 0 22075.8627
Rl516 out516 0 10
Vr517 ref517 0 0.59611175
E517 out517 0 ref517 fb517 1e6
R3_517 out517 fb517 100340.967
R4_517 fb517 0 21865.7628
Rl517 out517 0 10
Vr518 ref518 0 0.606532637
E518 out518 0 ref518 fb518 1e6
R3_518 out518 fb518 100182.132
R4_518 fb518 0 22139.5173
Rl518 out518 0 10
Vr519 ref519 0 0.605186896
E519 out519 0 ref519 fb519 1e6
R3_519 out519 fb519 100012.64
R4_519 fb519 0 22213.5738
Rl519 out519 0 10
Vr520 ref520 0 0.589629267
E520 out520 0 ref520 fb520 1e6
R3_520 out520 fb520 99114.99
R4_520 fb520 0 22103.412
Rl520 out520 0 10
Vr521 ref521 0 0.606054877
E521 out521 0 ref521 fb521 1e6
R3_521 out521 fb521 100241.024
R4_521 fb521 0 21936.3303
Rl521 out521 0 10
Vr522 ref522 0 0.594913903
E522 out522 0 ref522 fb522 1e6
R3_522 out522 fb522 100920.284
R4_522 fb522 0 21922.7707
Rl522 out522 0 10
Vr523 ref523 0 0.601071751
E523 out523 0 ref523 fb523 1e6
R3_523 out523 fb523 99661.8285
R4_523 fb523 0 22027.5489
Rl523 out523 0 10
Vr524 ref524 0 0.610888455
E524 out524 0 ref524 fb524 1e6
R3_524 out524 fb524 99512.7062
R4_524 fb524 0 21816.9731
Rl524 out524 0 10
Vr525 ref525 0 0.593502811
E525 out525 0 ref525 fb525 1e6
R3_525 out525 fb525 100871.107
R4_525 fb525 0 22011.3821
Rl525 out525 0 10
Vr526 ref526 0 0.596414963
E526 out526 0 ref526 fb526 1e6
R3_526 out526 fb526 99333.3747
R4_526 fb526 0 21837.1917
Rl526 out526 0 10
Vr527 ref527 0 0.588526179
E527 out527 0 ref527 fb527 1e6
R3_527 out527 fb527 99669.6698
R4_527 fb527 0 22092.2025
Rl527 out527 0 10
Vr528 ref528 0 0.597605501
E528 out528 0 ref528 fb528 1e6
R3_528 out528 fb528 100740.073
R4_528 fb528 0 21869.372
Rl528 out528 0 10
Vr529 ref529 0 0.604108338
E529 out529 0 ref529 fb529 1e6
R3_529 out529 fb529 100818.892
R4_529 fb529 0 21848.428
Rl529 out529 0 10
Vr530 ref530 0 0.594776865
E530 out530 0 ref530 fb530 1e6
R3_530 out530 fb530 99319.6155
R4_530 fb530 0 21797.9087
Rl530 out530 0 10
Vr531 ref531 0 0.606272725
E531 out531 0 ref531 fb531 1e6
R3_531 out531 fb531 100090.602
R4_531 fb531 0 22215.9585
Rl531 out531 0 10
Vr532 ref532 0 0.606045709
E532 out532 0 ref532 fb532 1e6
R3_532 out532 fb532 100102.073
R4_532 fb532 0 22082.3962
Rl532 out532 0 10
Vr533 ref533 0 0.594806098
E533 out533 0 ref533 fb533 1e6
R3_533 out533 fb533 100764.468
R4_533 fb533 0 21795.8218
Rl533 out533 0 10
Vr534 ref534 0 0.592923597
E534 out534 0 ref534 fb534 1e6
R3_534 out534 fb534 100189.546
R4_534 fb534 0 22113.6027
Rl534 out534 0 10
Vr535 ref535 0 0.611044887
E535 out535 0 ref535 fb535 1e6
R3_535 out535 fb535 99919.3974
R4_535 fb535 0 22167.756
Rl535 out535 0 10
Vr536 ref536 0 0.601833663
E536 out536 0 ref536 fb536 1e6
R3_536 out536 fb536 100343.094
R4_536 fb536 0 22025.6068
Rl536 out536 0 10
Vr537 ref537 0 0.588663663
E537 out537 0 ref537 fb537 1e6
R3_537 out537 fb537 100657.56
R4_537 fb537 0 21888.9616
Rl537 out537 0 10
Vr538 ref538 0 0.598063059
E538 out538 0 ref538 fb538 1e6
R3_538 out538 fb538 100868.297
R4_538 fb538 0 22065.8332
Rl538 out538 0 10
Vr539 ref539 0 0.588405191
E539 out539 0 ref539 fb539 1e6
R3_539 out539 fb539 100491.83
R4_539 fb539 0 22000.7342
Rl539 out539 0 10
Vr540 ref540 0 0.59940936
E540 out540 0 ref540 fb540 1e6
R3_540 out540 fb540 99000.3035
R4_540 fb540 0 22126.6924
Rl540 out540 0 10
Vr541 ref541 0 0.611311943
E541 out541 0 ref541 fb541 1e6
R3_541 out541 fb541 99982.4953
R4_541 fb541 0 22026.7241
Rl541 out541 0 10
Vr542 ref542 0 0.588178374
E542 out542 0 ref542 fb542 1e6
R3_542 out542 fb542 100121.354
R4_542 fb542 0 22125.6524
Rl542 out542 0 10
Vr543 ref543 0 0.610703591
E543 out543 0 ref543 fb543 1e6
R3_543 out543 fb543 99602.6354
R4_543 fb543 0 21926.0979
Rl543 out543 0 10
Vr544 ref544 0 0.594835888
E544 out544 0 ref544 fb544 1e6
R3_544 out544 fb544 99256.0008
R4_544 fb544 0 21987.9101
Rl544 out544 0 10
Vr545 ref545 0 0.590907942
E545 out545 0 ref545 fb545 1e6
R3_545 out545 fb545 100963.833
R4_545 fb545 0 21839.7049
Rl545 out545 0 10
Vr546 ref546 0 0.60861858
E546 out546 0 ref546 fb546 1e6
R3_546 out546 fb546 100729.203
R4_546 fb546 0 22201.4354
Rl546 out546 0 10
Vr547 ref547 0 0.588719788
E547 out547 0 ref547 fb547 1e6
R3_547 out547 fb547 100517.026
R4_547 fb547 0 21894.6919
Rl547 out547 0 10
Vr548 ref548 0 0.605360612
E548 out548 0 ref548 fb548 1e6
R3_548 out548 fb548 100059.763
R4_548 fb548 0 21825.1877
Rl548 out548 0 10
Vr549 ref549 0 0.598056946
E549 out549 0 ref549 fb549 1e6
R3_549 out549 fb549 99625.1405
R4_549 fb549 0 21937.8383
Rl549 out549 0 10
Vr550 ref550 0 0.607357994
E550 out550 0 ref550 fb550 1e6
R3_550 out550 fb550 100806.34
R4_550 fb550 0 22191.9952
Rl550 out550 0 10
Vr551 ref551 0 0.6024573
E551 out551 0 ref551 fb551 1e6
R3_551 out551 fb551 100217.646
R4_551 fb551 0 21817.2492
Rl551 out551 0 10
Vr552 ref552 0 0.599662865
E552 out552 0 ref552 fb552 1e6
R3_552 out552 fb552 100576.82
R4_552 fb552 0 21796.883
Rl552 out552 0 10
Vr553 ref553 0 0.60575357
E553 out553 0 ref553 fb553 1e6
R3_553 out553 fb553 99932.2532
R4_553 fb553 0 22003.827
Rl553 out553 0 10
Vr554 ref554 0 0.58957906
E554 out554 0 ref554 fb554 1e6
R3_554 out554 fb554 100061.42
R4_554 fb554 0 22208.043
Rl554 out554 0 10
Vr555 ref555 0 0.600710999
E555 out555 0 ref555 fb555 1e6
R3_555 out555 fb555 100432.938
R4_555 fb555 0 22080.607
Rl555 out555 0 10
Vr556 ref556 0 0.592208023
E556 out556 0 ref556 fb556 1e6
R3_556 out556 fb556 100925.205
R4_556 fb556 0 21859.2924
Rl556 out556 0 10
Vr557 ref557 0 0.608420625
E557 out557 0 ref557 fb557 1e6
R3_557 out557 fb557 100503.463
R4_557 fb557 0 22164.1604
Rl557 out557 0 10
Vr558 ref558 0 0.601626716
E558 out558 0 ref558 fb558 1e6
R3_558 out558 fb558 99062.8657
R4_558 fb558 0 21881.49
Rl558 out558 0 10
Vr559 ref559 0 0.602092873
E559 out559 0 ref559 fb559 1e6
R3_559 out559 fb559 100485.645
R4_559 fb559 0 21851.478
Rl559 out559 0 10
Vr560 ref560 0 0.591077185
E560 out560 0 ref560 fb560 1e6
R3_560 out560 fb560 99647.1037
R4_560 fb560 0 21905.205
Rl560 out560 0 10
Vr561 ref561 0 0.589047122
E561 out561 0 ref561 fb561 1e6
R3_561 out561 fb561 99123.5145
R4_561 fb561 0 22008.0963
Rl561 out561 0 10
Vr562 ref562 0 0.602671721
E562 out562 0 ref562 fb562 1e6
R3_562 out562 fb562 99868.8303
R4_562 fb562 0 21961.3618
Rl562 out562 0 10
Vr563 ref563 0 0.597912678
E563 out563 0 ref563 fb563 1e6
R3_563 out563 fb563 100218.612
R4_563 fb563 0 21946.3075
Rl563 out563 0 10
Vr564 ref564 0 0.604561928
E564 out564 0 ref564 fb564 1e6
R3_564 out564 fb564 100372.893
R4_564 fb564 0 22199.8927
Rl564 out564 0 10
Vr565 ref565 0 0.604471202
E565 out565 0 ref565 fb565 1e6
R3_565 out565 fb565 99944.3889
R4_565 fb565 0 22133.8764
Rl565 out565 0 10
Vr566 ref566 0 0.589625655
E566 out566 0 ref566 fb566 1e6
R3_566 out566 fb566 100604.948
R4_566 fb566 0 21970.3294
Rl566 out566 0 10
Vr567 ref567 0 0.603712903
E567 out567 0 ref567 fb567 1e6
R3_567 out567 fb567 99973.3683
R4_567 fb567 0 21948.8807
Rl567 out567 0 10
Vr568 ref568 0 0.606848439
E568 out568 0 ref568 fb568 1e6
R3_568 out568 fb568 99291.279
R4_568 fb568 0 22072.6241
Rl568 out568 0 10
Vr569 ref569 0 0.606428034
E569 out569 0 ref569 fb569 1e6
R3_569 out569 fb569 99790.2905
R4_569 fb569 0 22128.7791
Rl569 out569 0 10
Vr570 ref570 0 0.594202424
E570 out570 0 ref570 fb570 1e6
R3_570 out570 fb570 100423.108
R4_570 fb570 0 21816.6445
Rl570 out570 0 10
Vr571 ref571 0 0.600535318
E571 out571 0 ref571 fb571 1e6
R3_571 out571 fb571 100790.572
R4_571 fb571 0 22053.5777
Rl571 out571 0 10
Vr572 ref572 0 0.593323313
E572 out572 0 ref572 fb572 1e6
R3_572 out572 fb572 99045.6588
R4_572 fb572 0 22137.8
Rl572 out572 0 10
Vr573 ref573 0 0.601435818
E573 out573 0 ref573 fb573 1e6
R3_573 out573 fb573 100225.014
R4_573 fb573 0 21809.147
Rl573 out573 0 10
Vr574 ref574 0 0.590534394
E574 out574 0 ref574 fb574 1e6
R3_574 out574 fb574 99088.4493
R4_574 fb574 0 21916.2644
Rl574 out574 0 10
Vr575 ref575 0 0.607006895
E575 out575 0 ref575 fb575 1e6
R3_575 out575 fb575 100294.787
R4_575 fb575 0 21849.7795
Rl575 out575 0 10
Vr576 ref576 0 0.591717671
E576 out576 0 ref576 fb576 1e6
R3_576 out576 fb576 100202.174
R4_576 fb576 0 21903.5106
Rl576 out576 0 10
Vr577 ref577 0 0.609958349
E577 out577 0 ref577 fb577 1e6
R3_577 out577 fb577 99920.9688
R4_577 fb577 0 22110.9395
Rl577 out577 0 10
Vr578 ref578 0 0.595002652
E578 out578 0 ref578 fb578 1e6
R3_578 out578 fb578 100181.905
R4_578 fb578 0 22029.9878
Rl578 out578 0 10
Vr579 ref579 0 0.609319464
E579 out579 0 ref579 fb579 1e6
R3_579 out579 fb579 99297.8924
R4_579 fb579 0 22063.5235
Rl579 out579 0 10
Vr580 ref580 0 0.591424552
E580 out580 0 ref580 fb580 1e6
R3_580 out580 fb580 100037.71
R4_580 fb580 0 22172.7623
Rl580 out580 0 10
Vr581 ref581 0 0.599276244
E581 out581 0 ref581 fb581 1e6
R3_581 out581 fb581 100178.912
R4_581 fb581 0 22111.6607
Rl581 out581 0 10
Vr582 ref582 0 0.602481966
E582 out582 0 ref582 fb582 1e6
R3_582 out582 fb582 100003.664
R4_582 fb582 0 22025.3714
Rl582 out582 0 10
Vr583 ref583 0 0.609648234
E583 out583 0 ref583 fb583 1e6
R3_583 out583 fb583 99126.3293
R4_583 fb583 0 21839.5185
Rl583 out583 0 10
Vr584 ref584 0 0.606072816
E584 out584 0 ref584 fb584 1e6
R3_584 out584 fb584 99739.9646
R4_584 fb584 0 21850.0131
Rl584 out584 0 10
Vr585 ref585 0 0.595048539
E585 out585 0 ref585 fb585 1e6
R3_585 out585 fb585 99022.9532
R4_585 fb585 0 22141.7263
Rl585 out585 0 10
Vr586 ref586 0 0.611771522
E586 out586 0 ref586 fb586 1e6
R3_586 out586 fb586 100995.866
R4_586 fb586 0 21977.085
Rl586 out586 0 10
Vr587 ref587 0 0.610424382
E587 out587 0 ref587 fb587 1e6
R3_587 out587 fb587 99578.7091
R4_587 fb587 0 21985.4448
Rl587 out587 0 10
Vr588 ref588 0 0.593077149
E588 out588 0 ref588 fb588 1e6
R3_588 out588 fb588 99769.2098
R4_588 fb588 0 22201.7935
Rl588 out588 0 10
Vr589 ref589 0 0.606117663
E589 out589 0 ref589 fb589 1e6
R3_589 out589 fb589 100700.09
R4_589 fb589 0 22065.7683
Rl589 out589 0 10
Vr590 ref590 0 0.591556586
E590 out590 0 ref590 fb590 1e6
R3_590 out590 fb590 99164.3465
R4_590 fb590 0 21842.2755
Rl590 out590 0 10
Vr591 ref591 0 0.590348402
E591 out591 0 ref591 fb591 1e6
R3_591 out591 fb591 100182.001
R4_591 fb591 0 22182.6553
Rl591 out591 0 10
Vr592 ref592 0 0.592431448
E592 out592 0 ref592 fb592 1e6
R3_592 out592 fb592 100397.975
R4_592 fb592 0 21965.5029
Rl592 out592 0 10
Vr593 ref593 0 0.609085181
E593 out593 0 ref593 fb593 1e6
R3_593 out593 fb593 100276.573
R4_593 fb593 0 21785.5536
Rl593 out593 0 10
Vr594 ref594 0 0.593758305
E594 out594 0 ref594 fb594 1e6
R3_594 out594 fb594 100877.392
R4_594 fb594 0 21890.3666
Rl594 out594 0 10
Vr595 ref595 0 0.593258941
E595 out595 0 ref595 fb595 1e6
R3_595 out595 fb595 99698.9205
R4_595 fb595 0 22065.2006
Rl595 out595 0 10
Vr596 ref596 0 0.596904424
E596 out596 0 ref596 fb596 1e6
R3_596 out596 fb596 100043.719
R4_596 fb596 0 22088.9599
Rl596 out596 0 10
Vr597 ref597 0 0.590959305
E597 out597 0 ref597 fb597 1e6
R3_597 out597 fb597 100155.858
R4_597 fb597 0 21966.491
Rl597 out597 0 10
Vr598 ref598 0 0.602077698
E598 out598 0 ref598 fb598 1e6
R3_598 out598 fb598 99088.0098
R4_598 fb598 0 22036.0117
Rl598 out598 0 10
Vr599 ref599 0 0.61003502
E599 out599 0 ref599 fb599 1e6
R3_599 out599 fb599 100776.303
R4_599 fb599 0 22055.4106
Rl599 out599 0 10
Vr600 ref600 0 0.595672328
E600 out600 0 ref600 fb600 1e6
R3_600 out600 fb600 99995.3563
R4_600 fb600 0 22194.01
Rl600 out600 0 10
Vr601 ref601 0 0.592809238
E601 out601 0 ref601 fb601 1e6
R3_601 out601 fb601 99172.4816
R4_601 fb601 0 22090.2755
Rl601 out601 0 10
Vr602 ref602 0 0.611550403
E602 out602 0 ref602 fb602 1e6
R3_602 out602 fb602 100114.266
R4_602 fb602 0 22171.5799
Rl602 out602 0 10
Vr603 ref603 0 0.599756185
E603 out603 0 ref603 fb603 1e6
R3_603 out603 fb603 99729.1222
R4_603 fb603 0 22109.3369
Rl603 out603 0 10
Vr604 ref604 0 0.603623928
E604 out604 0 ref604 fb604 1e6
R3_604 out604 fb604 99206.2782
R4_604 fb604 0 22123.3974
Rl604 out604 0 10
Vr605 ref605 0 0.590502834
E605 out605 0 ref605 fb605 1e6
R3_605 out605 fb605 100973.082
R4_605 fb605 0 22082.1319
Rl605 out605 0 10
Vr606 ref606 0 0.596665043
E606 out606 0 ref606 fb606 1e6
R3_606 out606 fb606 99055.5777
R4_606 fb606 0 21813.9497
Rl606 out606 0 10
Vr607 ref607 0 0.594214501
E607 out607 0 ref607 fb607 1e6
R3_607 out607 fb607 100094.906
R4_607 fb607 0 21881.4751
Rl607 out607 0 10
Vr608 ref608 0 0.59753974
E608 out608 0 ref608 fb608 1e6
R3_608 out608 fb608 100213.585
R4_608 fb608 0 22066.2782
Rl608 out608 0 10
Vr609 ref609 0 0.604813584
E609 out609 0 ref609 fb609 1e6
R3_609 out609 fb609 100846.207
R4_609 fb609 0 22212.0549
Rl609 out609 0 10
Vr610 ref610 0 0.598075032
E610 out610 0 ref610 fb610 1e6
R3_610 out610 fb610 99237.9923
R4_610 fb610 0 21806.1142
Rl610 out610 0 10
Vr611 ref611 0 0.600197116
E611 out611 0 ref611 fb611 1e6
R3_611 out611 fb611 100371.312
R4_611 fb611 0 21798.0928
Rl611 out611 0 10
Vr612 ref612 0 0.608354251
E612 out612 0 ref612 fb612 1e6
R3_612 out612 fb612 99530.7931
R4_612 fb612 0 22152.0741
Rl612 out612 0 10
Vr613 ref613 0 0.596013687
E613 out613 0 ref613 fb613 1e6
R3_613 out613 fb613 99111.0232
R4_613 fb613 0 21945.3593
Rl613 out613 0 10
Vr614 ref614 0 0.606148712
E614 out614 0 ref614 fb614 1e6
R3_614 out614 fb614 100938.845
R4_614 fb614 0 22149.4112
Rl614 out614 0 10
Vr615 ref615 0 0.607903332
E615 out615 0 ref615 fb615 1e6
R3_615 out615 fb615 99167.0958
R4_615 fb615 0 22146.7934
Rl615 out615 0 10
Vr616 ref616 0 0.610144999
E616 out616 0 ref616 fb616 1e6
R3_616 out616 fb616 99186.043
R4_616 fb616 0 22157.595
Rl616 out616 0 10
Vr617 ref617 0 0.609369254
E617 out617 0 ref617 fb617 1e6
R3_617 out617 fb617 99152.2358
R4_617 fb617 0 21783.3462
Rl617 out617 0 10
Vr618 ref618 0 0.60233519
E618 out618 0 ref618 fb618 1e6
R3_618 out618 fb618 99938.6383
R4_618 fb618 0 22165.1677
Rl618 out618 0 10
Vr619 ref619 0 0.588624949
E619 out619 0 ref619 fb619 1e6
R3_619 out619 fb619 100658.806
R4_619 fb619 0 22146.2235
Rl619 out619 0 10
Vr620 ref620 0 0.603181956
E620 out620 0 ref620 fb620 1e6
R3_620 out620 fb620 99255.7543
R4_620 fb620 0 22073.0682
Rl620 out620 0 10
Vr621 ref621 0 0.592904607
E621 out621 0 ref621 fb621 1e6
R3_621 out621 fb621 100246.671
R4_621 fb621 0 21865.3014
Rl621 out621 0 10
Vr622 ref622 0 0.607083802
E622 out622 0 ref622 fb622 1e6
R3_622 out622 fb622 100720.039
R4_622 fb622 0 21787.0304
Rl622 out622 0 10
Vr623 ref623 0 0.603340288
E623 out623 0 ref623 fb623 1e6
R3_623 out623 fb623 100244.247
R4_623 fb623 0 21881.6752
Rl623 out623 0 10
Vr624 ref624 0 0.605685107
E624 out624 0 ref624 fb624 1e6
R3_624 out624 fb624 99411.6418
R4_624 fb624 0 22026.1699
Rl624 out624 0 10
Vr625 ref625 0 0.611537816
E625 out625 0 ref625 fb625 1e6
R3_625 out625 fb625 100797.626
R4_625 fb625 0 22182.0943
Rl625 out625 0 10
Vr626 ref626 0 0.595801194
E626 out626 0 ref626 fb626 1e6
R3_626 out626 fb626 100243.957
R4_626 fb626 0 21973.2564
Rl626 out626 0 10
Vr627 ref627 0 0.588782444
E627 out627 0 ref627 fb627 1e6
R3_627 out627 fb627 100708.094
R4_627 fb627 0 22216.9917
Rl627 out627 0 10
Vr628 ref628 0 0.597808188
E628 out628 0 ref628 fb628 1e6
R3_628 out628 fb628 99431.8138
R4_628 fb628 0 21900.6701
Rl628 out628 0 10
Vr629 ref629 0 0.601222065
E629 out629 0 ref629 fb629 1e6
R3_629 out629 fb629 99938.8333
R4_629 fb629 0 22098.4358
Rl629 out629 0 10
Vr630 ref630 0 0.598634687
E630 out630 0 ref630 fb630 1e6
R3_630 out630 fb630 100992.045
R4_630 fb630 0 21931.2277
Rl630 out630 0 10
Vr631 ref631 0 0.600373168
E631 out631 0 ref631 fb631 1e6
R3_631 out631 fb631 99802.3082
R4_631 fb631 0 22204.1552
Rl631 out631 0 10
Vr632 ref632 0 0.602177614
E632 out632 0 ref632 fb632 1e6
R3_632 out632 fb632 100308.421
R4_632 fb632 0 22095.8276
Rl632 out632 0 10
Vr633 ref633 0 0.609421156
E633 out633 0 ref633 fb633 1e6
R3_633 out633 fb633 100481.448
R4_633 fb633 0 21887.8082
Rl633 out633 0 10
Vr634 ref634 0 0.598907882
E634 out634 0 ref634 fb634 1e6
R3_634 out634 fb634 100076.632
R4_634 fb634 0 22096.0081
Rl634 out634 0 10
Vr635 ref635 0 0.590263987
E635 out635 0 ref635 fb635 1e6
R3_635 out635 fb635 100036.09
R4_635 fb635 0 22127.0671
Rl635 out635 0 10
Vr636 ref636 0 0.608982975
E636 out636 0 ref636 fb636 1e6
R3_636 out636 fb636 100267.861
R4_636 fb636 0 22086.0618
Rl636 out636 0 10
Vr637 ref637 0 0.588442599
E637 out637 0 ref637 fb637 1e6
R3_637 out637 fb637 99814.2788
R4_637 fb637 0 22103.3842
Rl637 out637 0 10
Vr638 ref638 0 0.594403172
E638 out638 0 ref638 fb638 1e6
R3_638 out638 fb638 100368.832
R4_638 fb638 0 22140.9078
Rl638 out638 0 10
Vr639 ref639 0 0.597124664
E639 out639 0 ref639 fb639 1e6
R3_639 out639 fb639 99920.0597
R4_639 fb639 0 22135.7076
Rl639 out639 0 10
Vr640 ref640 0 0.608893484
E640 out640 0 ref640 fb640 1e6
R3_640 out640 fb640 99193.3255
R4_640 fb640 0 22032.1442
Rl640 out640 0 10
Vr641 ref641 0 0.611660602
E641 out641 0 ref641 fb641 1e6
R3_641 out641 fb641 100140.669
R4_641 fb641 0 21785.3449
Rl641 out641 0 10
Vr642 ref642 0 0.596902158
E642 out642 0 ref642 fb642 1e6
R3_642 out642 fb642 100611.791
R4_642 fb642 0 22065.7116
Rl642 out642 0 10
Vr643 ref643 0 0.593381087
E643 out643 0 ref643 fb643 1e6
R3_643 out643 fb643 99422.7684
R4_643 fb643 0 21960.5471
Rl643 out643 0 10
Vr644 ref644 0 0.590900741
E644 out644 0 ref644 fb644 1e6
R3_644 out644 fb644 100111.523
R4_644 fb644 0 22219.1917
Rl644 out644 0 10
Vr645 ref645 0 0.600746821
E645 out645 0 ref645 fb645 1e6
R3_645 out645 fb645 100766.912
R4_645 fb645 0 21902.907
Rl645 out645 0 10
Vr646 ref646 0 0.597499393
E646 out646 0 ref646 fb646 1e6
R3_646 out646 fb646 99236.9762
R4_646 fb646 0 21900.0442
Rl646 out646 0 10
Vr647 ref647 0 0.589821001
E647 out647 0 ref647 fb647 1e6
R3_647 out647 fb647 99460.1401
R4_647 fb647 0 21817.1981
Rl647 out647 0 10
Vr648 ref648 0 0.599197856
E648 out648 0 ref648 fb648 1e6
R3_648 out648 fb648 100377.78
R4_648 fb648 0 21932.8047
Rl648 out648 0 10
Vr649 ref649 0 0.59784076
E649 out649 0 ref649 fb649 1e6
R3_649 out649 fb649 99934.4913
R4_649 fb649 0 22143.2384
Rl649 out649 0 10
Vr650 ref650 0 0.603285715
E650 out650 0 ref650 fb650 1e6
R3_650 out650 fb650 99229.6596
R4_650 fb650 0 22205.9814
Rl650 out650 0 10
Vr651 ref651 0 0.60093674
E651 out651 0 ref651 fb651 1e6
R3_651 out651 fb651 100656.296
R4_651 fb651 0 22058.0853
Rl651 out651 0 10
Vr652 ref652 0 0.595724002
E652 out652 0 ref652 fb652 1e6
R3_652 out652 fb652 100490.386
R4_652 fb652 0 21941.666
Rl652 out652 0 10
Vr653 ref653 0 0.608339032
E653 out653 0 ref653 fb653 1e6
R3_653 out653 fb653 100658.566
R4_653 fb653 0 21848.0034
Rl653 out653 0 10
Vr654 ref654 0 0.607274627
E654 out654 0 ref654 fb654 1e6
R3_654 out654 fb654 99597.8517
R4_654 fb654 0 21880.3497
Rl654 out654 0 10
Vr655 ref655 0 0.59553543
E655 out655 0 ref655 fb655 1e6
R3_655 out655 fb655 99181.7163
R4_655 fb655 0 21870.9528
Rl655 out655 0 10
Vr656 ref656 0 0.60572595
E656 out656 0 ref656 fb656 1e6
R3_656 out656 fb656 99985.0281
R4_656 fb656 0 22031.7441
Rl656 out656 0 10
Vr657 ref657 0 0.605542012
E657 out657 0 ref657 fb657 1e6
R3_657 out657 fb657 100346.033
R4_657 fb657 0 22200.0044
Rl657 out657 0 10
Vr658 ref658 0 0.605779847
E658 out658 0 ref658 fb658 1e6
R3_658 out658 fb658 100734.886
R4_658 fb658 0 22108.9803
Rl658 out658 0 10
Vr659 ref659 0 0.599528948
E659 out659 0 ref659 fb659 1e6
R3_659 out659 fb659 99233.0991
R4_659 fb659 0 22034.2645
Rl659 out659 0 10
Vr660 ref660 0 0.604060725
E660 out660 0 ref660 fb660 1e6
R3_660 out660 fb660 100277.423
R4_660 fb660 0 21930.5525
Rl660 out660 0 10
Vr661 ref661 0 0.594142264
E661 out661 0 ref661 fb661 1e6
R3_661 out661 fb661 99207.6928
R4_661 fb661 0 21959.9354
Rl661 out661 0 10
Vr662 ref662 0 0.601358907
E662 out662 0 ref662 fb662 1e6
R3_662 out662 fb662 99717.8414
R4_662 fb662 0 21973.5025
Rl662 out662 0 10
Vr663 ref663 0 0.608051741
E663 out663 0 ref663 fb663 1e6
R3_663 out663 fb663 99156.5476
R4_663 fb663 0 22063.5605
Rl663 out663 0 10
Vr664 ref664 0 0.606844931
E664 out664 0 ref664 fb664 1e6
R3_664 out664 fb664 100408.828
R4_664 fb664 0 22102.8602
Rl664 out664 0 10
Vr665 ref665 0 0.591014041
E665 out665 0 ref665 fb665 1e6
R3_665 out665 fb665 99028.8321
R4_665 fb665 0 21800.3412
Rl665 out665 0 10
Vr666 ref666 0 0.603580686
E666 out666 0 ref666 fb666 1e6
R3_666 out666 fb666 99745.6918
R4_666 fb666 0 22173.7298
Rl666 out666 0 10
Vr667 ref667 0 0.599889151
E667 out667 0 ref667 fb667 1e6
R3_667 out667 fb667 100247.418
R4_667 fb667 0 22156.9572
Rl667 out667 0 10
Vr668 ref668 0 0.597122809
E668 out668 0 ref668 fb668 1e6
R3_668 out668 fb668 100123.301
R4_668 fb668 0 21792.1956
Rl668 out668 0 10
Vr669 ref669 0 0.597293231
E669 out669 0 ref669 fb669 1e6
R3_669 out669 fb669 100975.838
R4_669 fb669 0 22088.6576
Rl669 out669 0 10
Vr670 ref670 0 0.607900354
E670 out670 0 ref670 fb670 1e6
R3_670 out670 fb670 99372.2227
R4_670 fb670 0 21904.9422
Rl670 out670 0 10
Vr671 ref671 0 0.60603258
E671 out671 0 ref671 fb671 1e6
R3_671 out671 fb671 100780.665
R4_671 fb671 0 21975.0794
Rl671 out671 0 10
Vr672 ref672 0 0.602123286
E672 out672 0 ref672 fb672 1e6
R3_672 out672 fb672 100129.718
R4_672 fb672 0 21914.5776
Rl672 out672 0 10
Vr673 ref673 0 0.598009741
E673 out673 0 ref673 fb673 1e6
R3_673 out673 fb673 100765.403
R4_673 fb673 0 22098.5368
Rl673 out673 0 10
Vr674 ref674 0 0.603735766
E674 out674 0 ref674 fb674 1e6
R3_674 out674 fb674 99855.0449
R4_674 fb674 0 21784.2202
Rl674 out674 0 10
Vr675 ref675 0 0.595238118
E675 out675 0 ref675 fb675 1e6
R3_675 out675 fb675 99648.0493
R4_675 fb675 0 22105.8927
Rl675 out675 0 10
Vr676 ref676 0 0.610488406
E676 out676 0 ref676 fb676 1e6
R3_676 out676 fb676 99696.4084
R4_676 fb676 0 21953.6124
Rl676 out676 0 10
Vr677 ref677 0 0.589818901
E677 out677 0 ref677 fb677 1e6
R3_677 out677 fb677 99393.0164
R4_677 fb677 0 22119.4153
Rl677 out677 0 10
Vr678 ref678 0 0.597624569
E678 out678 0 ref678 fb678 1e6
R3_678 out678 fb678 99392.0009
R4_678 fb678 0 21923.5797
Rl678 out678 0 10
Vr679 ref679 0 0.606726679
E679 out679 0 ref679 fb679 1e6
R3_679 out679 fb679 100134.885
R4_679 fb679 0 22057.481
Rl679 out679 0 10
Vr680 ref680 0 0.607276683
E680 out680 0 ref680 fb680 1e6
R3_680 out680 fb680 99075.8826
R4_680 fb680 0 21971.8554
Rl680 out680 0 10
Vr681 ref681 0 0.588773844
E681 out681 0 ref681 fb681 1e6
R3_681 out681 fb681 99219.6332
R4_681 fb681 0 22057.3764
Rl681 out681 0 10
Vr682 ref682 0 0.610543088
E682 out682 0 ref682 fb682 1e6
R3_682 out682 fb682 100328.504
R4_682 fb682 0 21789.635
Rl682 out682 0 10
Vr683 ref683 0 0.598207545
E683 out683 0 ref683 fb683 1e6
R3_683 out683 fb683 99689.8909
R4_683 fb683 0 21915.1674
Rl683 out683 0 10
Vr684 ref684 0 0.590176841
E684 out684 0 ref684 fb684 1e6
R3_684 out684 fb684 99742.3396
R4_684 fb684 0 22103.0153
Rl684 out684 0 10
Vr685 ref685 0 0.594196564
E685 out685 0 ref685 fb685 1e6
R3_685 out685 fb685 100093.003
R4_685 fb685 0 21859.1154
Rl685 out685 0 10
Vr686 ref686 0 0.605174798
E686 out686 0 ref686 fb686 1e6
R3_686 out686 fb686 100512.835
R4_686 fb686 0 21810.1763
Rl686 out686 0 10
Vr687 ref687 0 0.588348482
E687 out687 0 ref687 fb687 1e6
R3_687 out687 fb687 100984.524
R4_687 fb687 0 22172.7312
Rl687 out687 0 10
Vr688 ref688 0 0.58899951
E688 out688 0 ref688 fb688 1e6
R3_688 out688 fb688 99097.9439
R4_688 fb688 0 22155.1135
Rl688 out688 0 10
Vr689 ref689 0 0.596458491
E689 out689 0 ref689 fb689 1e6
R3_689 out689 fb689 100386.917
R4_689 fb689 0 22002.8548
Rl689 out689 0 10
Vr690 ref690 0 0.59674686
E690 out690 0 ref690 fb690 1e6
R3_690 out690 fb690 99847.5058
R4_690 fb690 0 22024.4553
Rl690 out690 0 10
Vr691 ref691 0 0.590088108
E691 out691 0 ref691 fb691 1e6
R3_691 out691 fb691 100970.141
R4_691 fb691 0 21849.6829
Rl691 out691 0 10
Vr692 ref692 0 0.597234311
E692 out692 0 ref692 fb692 1e6
R3_692 out692 fb692 99132.7083
R4_692 fb692 0 21949.3151
Rl692 out692 0 10
Vr693 ref693 0 0.60958677
E693 out693 0 ref693 fb693 1e6
R3_693 out693 fb693 99139.48
R4_693 fb693 0 22219.1385
Rl693 out693 0 10
Vr694 ref694 0 0.594028145
E694 out694 0 ref694 fb694 1e6
R3_694 out694 fb694 99687.6799
R4_694 fb694 0 21961.8711
Rl694 out694 0 10
Vr695 ref695 0 0.606873747
E695 out695 0 ref695 fb695 1e6
R3_695 out695 fb695 99031.4302
R4_695 fb695 0 22093.4339
Rl695 out695 0 10
Vr696 ref696 0 0.599618167
E696 out696 0 ref696 fb696 1e6
R3_696 out696 fb696 99368.4638
R4_696 fb696 0 22128.5639
Rl696 out696 0 10
Vr697 ref697 0 0.601298715
E697 out697 0 ref697 fb697 1e6
R3_697 out697 fb697 100775.326
R4_697 fb697 0 22135.0144
Rl697 out697 0 10
Vr698 ref698 0 0.593094671
E698 out698 0 ref698 fb698 1e6
R3_698 out698 fb698 100415.324
R4_698 fb698 0 21945.2415
Rl698 out698 0 10
Vr699 ref699 0 0.595651353
E699 out699 0 ref699 fb699 1e6
R3_699 out699 fb699 99806.4742
R4_699 fb699 0 21826.7651
Rl699 out699 0 10
Vr700 ref700 0 0.594938258
E700 out700 0 ref700 fb700 1e6
R3_700 out700 fb700 99341.5431
R4_700 fb700 0 21978.6721
Rl700 out700 0 10
Vr701 ref701 0 0.597087152
E701 out701 0 ref701 fb701 1e6
R3_701 out701 fb701 100844.607
R4_701 fb701 0 22094.2866
Rl701 out701 0 10
Vr702 ref702 0 0.604638788
E702 out702 0 ref702 fb702 1e6
R3_702 out702 fb702 99911.4233
R4_702 fb702 0 21844.3444
Rl702 out702 0 10
Vr703 ref703 0 0.606629549
E703 out703 0 ref703 fb703 1e6
R3_703 out703 fb703 99883.8428
R4_703 fb703 0 22155.2132
Rl703 out703 0 10
Vr704 ref704 0 0.596705833
E704 out704 0 ref704 fb704 1e6
R3_704 out704 fb704 99513.7776
R4_704 fb704 0 21958.5408
Rl704 out704 0 10
Vr705 ref705 0 0.60041073
E705 out705 0 ref705 fb705 1e6
R3_705 out705 fb705 100914.369
R4_705 fb705 0 22085.0971
Rl705 out705 0 10
Vr706 ref706 0 0.590586484
E706 out706 0 ref706 fb706 1e6
R3_706 out706 fb706 99020.4859
R4_706 fb706 0 21866.1845
Rl706 out706 0 10
Vr707 ref707 0 0.59895376
E707 out707 0 ref707 fb707 1e6
R3_707 out707 fb707 100953.963
R4_707 fb707 0 21830.9138
Rl707 out707 0 10
Vr708 ref708 0 0.598970095
E708 out708 0 ref708 fb708 1e6
R3_708 out708 fb708 100371.471
R4_708 fb708 0 21836.4556
Rl708 out708 0 10
Vr709 ref709 0 0.603277198
E709 out709 0 ref709 fb709 1e6
R3_709 out709 fb709 100222.57
R4_709 fb709 0 22019.8748
Rl709 out709 0 10
Vr710 ref710 0 0.598977152
E710 out710 0 ref710 fb710 1e6
R3_710 out710 fb710 99866.5876
R4_710 fb710 0 21958.8534
Rl710 out710 0 10
Vr711 ref711 0 0.610892274
E711 out711 0 ref711 fb711 1e6
R3_711 out711 fb711 99398.2238
R4_711 fb711 0 21860.4463
Rl711 out711 0 10
Vr712 ref712 0 0.59110928
E712 out712 0 ref712 fb712 1e6
R3_712 out712 fb712 99043.2947
R4_712 fb712 0 21814.0566
Rl712 out712 0 10
Vr713 ref713 0 0.606687631
E713 out713 0 ref713 fb713 1e6
R3_713 out713 fb713 100957.812
R4_713 fb713 0 22138.4476
Rl713 out713 0 10
Vr714 ref714 0 0.60684709
E714 out714 0 ref714 fb714 1e6
R3_714 out714 fb714 100104.263
R4_714 fb714 0 22106.2174
Rl714 out714 0 10
Vr715 ref715 0 0.599831378
E715 out715 0 ref715 fb715 1e6
R3_715 out715 fb715 99457.2118
R4_715 fb715 0 21954.1894
Rl715 out715 0 10
Vr716 ref716 0 0.601553042
E716 out716 0 ref716 fb716 1e6
R3_716 out716 fb716 99344.7572
R4_716 fb716 0 22030.444
Rl716 out716 0 10
Vr717 ref717 0 0.59063198
E717 out717 0 ref717 fb717 1e6
R3_717 out717 fb717 99357.2659
R4_717 fb717 0 21938.1413
Rl717 out717 0 10
Vr718 ref718 0 0.603896248
E718 out718 0 ref718 fb718 1e6
R3_718 out718 fb718 100569.61
R4_718 fb718 0 21919.4359
Rl718 out718 0 10
Vr719 ref719 0 0.588561311
E719 out719 0 ref719 fb719 1e6
R3_719 out719 fb719 99699.4273
R4_719 fb719 0 22096.2139
Rl719 out719 0 10
Vr720 ref720 0 0.590859553
E720 out720 0 ref720 fb720 1e6
R3_720 out720 fb720 100425.295
R4_720 fb720 0 22055.8218
Rl720 out720 0 10
Vr721 ref721 0 0.596123629
E721 out721 0 ref721 fb721 1e6
R3_721 out721 fb721 99844.6983
R4_721 fb721 0 21903.4961
Rl721 out721 0 10
Vr722 ref722 0 0.597661646
E722 out722 0 ref722 fb722 1e6
R3_722 out722 fb722 100852.278
R4_722 fb722 0 21921.3842
Rl722 out722 0 10
Vr723 ref723 0 0.605832842
E723 out723 0 ref723 fb723 1e6
R3_723 out723 fb723 99995.8587
R4_723 fb723 0 22209.543
Rl723 out723 0 10
Vr724 ref724 0 0.600682206
E724 out724 0 ref724 fb724 1e6
R3_724 out724 fb724 99362.816
R4_724 fb724 0 22057.4138
Rl724 out724 0 10
Vr725 ref725 0 0.60590671
E725 out725 0 ref725 fb725 1e6
R3_725 out725 fb725 100088.776
R4_725 fb725 0 21980.5183
Rl725 out725 0 10
Vr726 ref726 0 0.598948752
E726 out726 0 ref726 fb726 1e6
R3_726 out726 fb726 99127.4873
R4_726 fb726 0 22128.1989
Rl726 out726 0 10
Vr727 ref727 0 0.608651502
E727 out727 0 ref727 fb727 1e6
R3_727 out727 fb727 99440.4944
R4_727 fb727 0 22184.1586
Rl727 out727 0 10
Vr728 ref728 0 0.603694434
E728 out728 0 ref728 fb728 1e6
R3_728 out728 fb728 100721.61
R4_728 fb728 0 21980.077
Rl728 out728 0 10
Vr729 ref729 0 0.591960216
E729 out729 0 ref729 fb729 1e6
R3_729 out729 fb729 100401.978
R4_729 fb729 0 22204.3514
Rl729 out729 0 10
Vr730 ref730 0 0.595795272
E730 out730 0 ref730 fb730 1e6
R3_730 out730 fb730 99670.4452
R4_730 fb730 0 22182.5413
Rl730 out730 0 10
Vr731 ref731 0 0.601370283
E731 out731 0 ref731 fb731 1e6
R3_731 out731 fb731 100182.79
R4_731 fb731 0 21901.2713
Rl731 out731 0 10
Vr732 ref732 0 0.607563014
E732 out732 0 ref732 fb732 1e6
R3_732 out732 fb732 100794.885
R4_732 fb732 0 21955.4899
Rl732 out732 0 10
Vr733 ref733 0 0.607588658
E733 out733 0 ref733 fb733 1e6
R3_733 out733 fb733 99902.2678
R4_733 fb733 0 21978.0415
Rl733 out733 0 10
Vr734 ref734 0 0.595487109
E734 out734 0 ref734 fb734 1e6
R3_734 out734 fb734 100643.825
R4_734 fb734 0 21988.4082
Rl734 out734 0 10
Vr735 ref735 0 0.589462871
E735 out735 0 ref735 fb735 1e6
R3_735 out735 fb735 99562.6347
R4_735 fb735 0 21980.0538
Rl735 out735 0 10
Vr736 ref736 0 0.606630903
E736 out736 0 ref736 fb736 1e6
R3_736 out736 fb736 99529.6225
R4_736 fb736 0 22212.1228
Rl736 out736 0 10
Vr737 ref737 0 0.609727585
E737 out737 0 ref737 fb737 1e6
R3_737 out737 fb737 100577.436
R4_737 fb737 0 21929.3086
Rl737 out737 0 10
Vr738 ref738 0 0.609957946
E738 out738 0 ref738 fb738 1e6
R3_738 out738 fb738 100224.835
R4_738 fb738 0 21813.8033
Rl738 out738 0 10
Vr739 ref739 0 0.589327393
E739 out739 0 ref739 fb739 1e6
R3_739 out739 fb739 100103.512
R4_739 fb739 0 22131.4433
Rl739 out739 0 10
Vr740 ref740 0 0.601911501
E740 out740 0 ref740 fb740 1e6
R3_740 out740 fb740 100398.236
R4_740 fb740 0 21929.0958
Rl740 out740 0 10
Vr741 ref741 0 0.598609607
E741 out741 0 ref741 fb741 1e6
R3_741 out741 fb741 100034.659
R4_741 fb741 0 21934.2468
Rl741 out741 0 10
Vr742 ref742 0 0.610840498
E742 out742 0 ref742 fb742 1e6
R3_742 out742 fb742 100164.692
R4_742 fb742 0 21829.174
Rl742 out742 0 10
Vr743 ref743 0 0.596924415
E743 out743 0 ref743 fb743 1e6
R3_743 out743 fb743 100068.475
R4_743 fb743 0 21879.576
Rl743 out743 0 10
Vr744 ref744 0 0.6091726
E744 out744 0 ref744 fb744 1e6
R3_744 out744 fb744 100690.568
R4_744 fb744 0 21923.5666
Rl744 out744 0 10
Vr745 ref745 0 0.598793609
E745 out745 0 ref745 fb745 1e6
R3_745 out745 fb745 100450.712
R4_745 fb745 0 22175.8164
Rl745 out745 0 10
Vr746 ref746 0 0.594044471
E746 out746 0 ref746 fb746 1e6
R3_746 out746 fb746 100130.847
R4_746 fb746 0 22170.7274
Rl746 out746 0 10
Vr747 ref747 0 0.603536369
E747 out747 0 ref747 fb747 1e6
R3_747 out747 fb747 100112.893
R4_747 fb747 0 22034.7439
Rl747 out747 0 10
Vr748 ref748 0 0.598607759
E748 out748 0 ref748 fb748 1e6
R3_748 out748 fb748 99700.5678
R4_748 fb748 0 22156.8693
Rl748 out748 0 10
Vr749 ref749 0 0.598499609
E749 out749 0 ref749 fb749 1e6
R3_749 out749 fb749 99797.1695
R4_749 fb749 0 22138.3792
Rl749 out749 0 10
Vr750 ref750 0 0.595671593
E750 out750 0 ref750 fb750 1e6
R3_750 out750 fb750 99779.1924
R4_750 fb750 0 21888.5186
Rl750 out750 0 10
Vr751 ref751 0 0.602050839
E751 out751 0 ref751 fb751 1e6
R3_751 out751 fb751 99715.4972
R4_751 fb751 0 22125.7418
Rl751 out751 0 10
Vr752 ref752 0 0.607682754
E752 out752 0 ref752 fb752 1e6
R3_752 out752 fb752 99645.1201
R4_752 fb752 0 21907.4567
Rl752 out752 0 10
Vr753 ref753 0 0.594142609
E753 out753 0 ref753 fb753 1e6
R3_753 out753 fb753 99418.3356
R4_753 fb753 0 22027.0191
Rl753 out753 0 10
Vr754 ref754 0 0.595038178
E754 out754 0 ref754 fb754 1e6
R3_754 out754 fb754 99811.467
R4_754 fb754 0 21999.4639
Rl754 out754 0 10
Vr755 ref755 0 0.598239265
E755 out755 0 ref755 fb755 1e6
R3_755 out755 fb755 100414.816
R4_755 fb755 0 22063.1667
Rl755 out755 0 10
Vr756 ref756 0 0.604048898
E756 out756 0 ref756 fb756 1e6
R3_756 out756 fb756 100947.757
R4_756 fb756 0 21930.0953
Rl756 out756 0 10
Vr757 ref757 0 0.611364125
E757 out757 0 ref757 fb757 1e6
R3_757 out757 fb757 100953.75
R4_757 fb757 0 21898.2469
Rl757 out757 0 10
Vr758 ref758 0 0.610752909
E758 out758 0 ref758 fb758 1e6
R3_758 out758 fb758 100142.909
R4_758 fb758 0 22074.7902
Rl758 out758 0 10
Vr759 ref759 0 0.599405142
E759 out759 0 ref759 fb759 1e6
R3_759 out759 fb759 99867.2874
R4_759 fb759 0 22142.8177
Rl759 out759 0 10
Vr760 ref760 0 0.596846162
E760 out760 0 ref760 fb760 1e6
R3_760 out760 fb760 99006.7667
R4_760 fb760 0 22131.1794
Rl760 out760 0 10
Vr761 ref761 0 0.604524241
E761 out761 0 ref761 fb761 1e6
R3_761 out761 fb761 100859.622
R4_761 fb761 0 21957.0338
Rl761 out761 0 10
Vr762 ref762 0 0.61027621
E762 out762 0 ref762 fb762 1e6
R3_762 out762 fb762 99525.1855
R4_762 fb762 0 22017.8708
Rl762 out762 0 10
Vr763 ref763 0 0.58835199
E763 out763 0 ref763 fb763 1e6
R3_763 out763 fb763 100905.352
R4_763 fb763 0 21877.198
Rl763 out763 0 10
Vr764 ref764 0 0.603729378
E764 out764 0 ref764 fb764 1e6
R3_764 out764 fb764 100968.878
R4_764 fb764 0 21930.065
Rl764 out764 0 10
Vr765 ref765 0 0.601436389
E765 out765 0 ref765 fb765 1e6
R3_765 out765 fb765 100203.72
R4_765 fb765 0 22120.108
Rl765 out765 0 10
Vr766 ref766 0 0.588203836
E766 out766 0 ref766 fb766 1e6
R3_766 out766 fb766 100053.415
R4_766 fb766 0 22054.6608
Rl766 out766 0 10
Vr767 ref767 0 0.58957025
E767 out767 0 ref767 fb767 1e6
R3_767 out767 fb767 100748.972
R4_767 fb767 0 22129.9797
Rl767 out767 0 10
Vr768 ref768 0 0.599859439
E768 out768 0 ref768 fb768 1e6
R3_768 out768 fb768 99536.385
R4_768 fb768 0 21991.3201
Rl768 out768 0 10
Vr769 ref769 0 0.596680408
E769 out769 0 ref769 fb769 1e6
R3_769 out769 fb769 100741.188
R4_769 fb769 0 22010.7648
Rl769 out769 0 10
Vr770 ref770 0 0.610308301
E770 out770 0 ref770 fb770 1e6
R3_770 out770 fb770 100749.399
R4_770 fb770 0 21953.6575
Rl770 out770 0 10
Vr771 ref771 0 0.602008035
E771 out771 0 ref771 fb771 1e6
R3_771 out771 fb771 100596.502
R4_771 fb771 0 22013.661
Rl771 out771 0 10
Vr772 ref772 0 0.607054353
E772 out772 0 ref772 fb772 1e6
R3_772 out772 fb772 100547.044
R4_772 fb772 0 22087.0248
Rl772 out772 0 10
Vr773 ref773 0 0.593240574
E773 out773 0 ref773 fb773 1e6
R3_773 out773 fb773 100046.777
R4_773 fb773 0 22015.6988
Rl773 out773 0 10
Vr774 ref774 0 0.608240262
E774 out774 0 ref774 fb774 1e6
R3_774 out774 fb774 99555.3666
R4_774 fb774 0 22143.4882
Rl774 out774 0 10
Vr775 ref775 0 0.596919931
E775 out775 0 ref775 fb775 1e6
R3_775 out775 fb775 100731.463
R4_775 fb775 0 22021.4747
Rl775 out775 0 10
Vr776 ref776 0 0.589349359
E776 out776 0 ref776 fb776 1e6
R3_776 out776 fb776 99409.3503
R4_776 fb776 0 21980.7931
Rl776 out776 0 10
Vr777 ref777 0 0.611700142
E777 out777 0 ref777 fb777 1e6
R3_777 out777 fb777 100331.521
R4_777 fb777 0 21786.9072
Rl777 out777 0 10
Vr778 ref778 0 0.609315936
E778 out778 0 ref778 fb778 1e6
R3_778 out778 fb778 99454.034
R4_778 fb778 0 21848.2597
Rl778 out778 0 10
Vr779 ref779 0 0.591852143
E779 out779 0 ref779 fb779 1e6
R3_779 out779 fb779 100259.531
R4_779 fb779 0 21815.1622
Rl779 out779 0 10
Vr780 ref780 0 0.611995445
E780 out780 0 ref780 fb780 1e6
R3_780 out780 fb780 100255.022
R4_780 fb780 0 21825.9893
Rl780 out780 0 10
Vr781 ref781 0 0.590334822
E781 out781 0 ref781 fb781 1e6
R3_781 out781 fb781 99524.5862
R4_781 fb781 0 21933.1809
Rl781 out781 0 10
Vr782 ref782 0 0.592103015
E782 out782 0 ref782 fb782 1e6
R3_782 out782 fb782 99366.009
R4_782 fb782 0 21889.1168
Rl782 out782 0 10
Vr783 ref783 0 0.600653923
E783 out783 0 ref783 fb783 1e6
R3_783 out783 fb783 99971.0629
R4_783 fb783 0 22191.2358
Rl783 out783 0 10
Vr784 ref784 0 0.595117684
E784 out784 0 ref784 fb784 1e6
R3_784 out784 fb784 99989.3056
R4_784 fb784 0 22022.1339
Rl784 out784 0 10
Vr785 ref785 0 0.610839489
E785 out785 0 ref785 fb785 1e6
R3_785 out785 fb785 100871.985
R4_785 fb785 0 22036.1514
Rl785 out785 0 10
Vr786 ref786 0 0.592620629
E786 out786 0 ref786 fb786 1e6
R3_786 out786 fb786 99212.0604
R4_786 fb786 0 22077.3637
Rl786 out786 0 10
Vr787 ref787 0 0.591936704
E787 out787 0 ref787 fb787 1e6
R3_787 out787 fb787 99234.8765
R4_787 fb787 0 22013.6669
Rl787 out787 0 10
Vr788 ref788 0 0.60601617
E788 out788 0 ref788 fb788 1e6
R3_788 out788 fb788 99921.051
R4_788 fb788 0 22176.3633
Rl788 out788 0 10
Vr789 ref789 0 0.593725088
E789 out789 0 ref789 fb789 1e6
R3_789 out789 fb789 100221.63
R4_789 fb789 0 22013.1827
Rl789 out789 0 10
Vr790 ref790 0 0.599709431
E790 out790 0 ref790 fb790 1e6
R3_790 out790 fb790 100153.061
R4_790 fb790 0 21876.0116
Rl790 out790 0 10
Vr791 ref791 0 0.605618223
E791 out791 0 ref791 fb791 1e6
R3_791 out791 fb791 99172.208
R4_791 fb791 0 21949.509
Rl791 out791 0 10
Vr792 ref792 0 0.59031782
E792 out792 0 ref792 fb792 1e6
R3_792 out792 fb792 99548.9825
R4_792 fb792 0 22131.0841
Rl792 out792 0 10
Vr793 ref793 0 0.604145705
E793 out793 0 ref793 fb793 1e6
R3_793 out793 fb793 100880.509
R4_793 fb793 0 21946.0882
Rl793 out793 0 10
Vr794 ref794 0 0.597186527
E794 out794 0 ref794 fb794 1e6
R3_794 out794 fb794 99088.0567
R4_794 fb794 0 22214.5301
Rl794 out794 0 10
Vr795 ref795 0 0.591968857
E795 out795 0 ref795 fb795 1e6
R3_795 out795 fb795 100614.945
R4_795 fb795 0 22060.2438
Rl795 out795 0 10
Vr796 ref796 0 0.610005721
E796 out796 0 ref796 fb796 1e6
R3_796 out796 fb796 100859.127
R4_796 fb796 0 22090.7588
Rl796 out796 0 10
Vr797 ref797 0 0.598525735
E797 out797 0 ref797 fb797 1e6
R3_797 out797 fb797 100749.951
R4_797 fb797 0 22145.2581
Rl797 out797 0 10
Vr798 ref798 0 0.595224868
E798 out798 0 ref798 fb798 1e6
R3_798 out798 fb798 99833.4923
R4_798 fb798 0 21808.2593
Rl798 out798 0 10
Vr799 ref799 0 0.597372244
E799 out799 0 ref799 fb799 1e6
R3_799 out799 fb799 99915.3264
R4_799 fb799 0 22036.7851
Rl799 out799 0 10
Vr800 ref800 0 0.600346575
E800 out800 0 ref800 fb800 1e6
R3_800 out800 fb800 99354.8128
R4_800 fb800 0 21842.027
Rl800 out800 0 10
Vr801 ref801 0 0.589665348
E801 out801 0 ref801 fb801 1e6
R3_801 out801 fb801 100694.112
R4_801 fb801 0 21809.4728
Rl801 out801 0 10
Vr802 ref802 0 0.606383129
E802 out802 0 ref802 fb802 1e6
R3_802 out802 fb802 100256.236
R4_802 fb802 0 21973.5334
Rl802 out802 0 10
Vr803 ref803 0 0.596042244
E803 out803 0 ref803 fb803 1e6
R3_803 out803 fb803 100070.199
R4_803 fb803 0 22082.9321
Rl803 out803 0 10
Vr804 ref804 0 0.604874758
E804 out804 0 ref804 fb804 1e6
R3_804 out804 fb804 100754.72
R4_804 fb804 0 21982.3894
Rl804 out804 0 10
Vr805 ref805 0 0.60207172
E805 out805 0 ref805 fb805 1e6
R3_805 out805 fb805 100174.454
R4_805 fb805 0 21929.3324
Rl805 out805 0 10
Vr806 ref806 0 0.593864304
E806 out806 0 ref806 fb806 1e6
R3_806 out806 fb806 99268.6987
R4_806 fb806 0 21841.967
Rl806 out806 0 10
Vr807 ref807 0 0.597305642
E807 out807 0 ref807 fb807 1e6
R3_807 out807 fb807 99259.6995
R4_807 fb807 0 21961.3967
Rl807 out807 0 10
Vr808 ref808 0 0.592916261
E808 out808 0 ref808 fb808 1e6
R3_808 out808 fb808 99726.1692
R4_808 fb808 0 21966.1677
Rl808 out808 0 10
Vr809 ref809 0 0.608951408
E809 out809 0 ref809 fb809 1e6
R3_809 out809 fb809 100304.822
R4_809 fb809 0 22032.5244
Rl809 out809 0 10
Vr810 ref810 0 0.605746641
E810 out810 0 ref810 fb810 1e6
R3_810 out810 fb810 100177.814
R4_810 fb810 0 22031.3402
Rl810 out810 0 10
Vr811 ref811 0 0.610391697
E811 out811 0 ref811 fb811 1e6
R3_811 out811 fb811 99282.1446
R4_811 fb811 0 22111.4636
Rl811 out811 0 10
Vr812 ref812 0 0.593067168
E812 out812 0 ref812 fb812 1e6
R3_812 out812 fb812 100496.334
R4_812 fb812 0 22213.5225
Rl812 out812 0 10
Vr813 ref813 0 0.597533398
E813 out813 0 ref813 fb813 1e6
R3_813 out813 fb813 99314.0521
R4_813 fb813 0 22160.5962
Rl813 out813 0 10
Vr814 ref814 0 0.596973928
E814 out814 0 ref814 fb814 1e6
R3_814 out814 fb814 99762.8138
R4_814 fb814 0 22206.7888
Rl814 out814 0 10
Vr815 ref815 0 0.603055591
E815 out815 0 ref815 fb815 1e6
R3_815 out815 fb815 99605.5712
R4_815 fb815 0 21898.7959
Rl815 out815 0 10
Vr816 ref816 0 0.595341156
E816 out816 0 ref816 fb816 1e6
R3_816 out816 fb816 100445.013
R4_816 fb816 0 21954.1543
Rl816 out816 0 10
Vr817 ref817 0 0.607056099
E817 out817 0 ref817 fb817 1e6
R3_817 out817 fb817 99769.1689
R4_817 fb817 0 22040.9644
Rl817 out817 0 10
Vr818 ref818 0 0.590808464
E818 out818 0 ref818 fb818 1e6
R3_818 out818 fb818 99595.3613
R4_818 fb818 0 22214.0507
Rl818 out818 0 10
Vr819 ref819 0 0.596062106
E819 out819 0 ref819 fb819 1e6
R3_819 out819 fb819 100043.92
R4_819 fb819 0 22137.7594
Rl819 out819 0 10
Vr820 ref820 0 0.593904369
E820 out820 0 ref820 fb820 1e6
R3_820 out820 fb820 100137.033
R4_820 fb820 0 22023.033
Rl820 out820 0 10
Vr821 ref821 0 0.590668547
E821 out821 0 ref821 fb821 1e6
R3_821 out821 fb821 100322.728
R4_821 fb821 0 22207.9349
Rl821 out821 0 10
Vr822 ref822 0 0.606601993
E822 out822 0 ref822 fb822 1e6
R3_822 out822 fb822 100405.948
R4_822 fb822 0 21998.5778
Rl822 out822 0 10
Vr823 ref823 0 0.607340332
E823 out823 0 ref823 fb823 1e6
R3_823 out823 fb823 99767.2887
R4_823 fb823 0 22121.1025
Rl823 out823 0 10
Vr824 ref824 0 0.602514429
E824 out824 0 ref824 fb824 1e6
R3_824 out824 fb824 100862.311
R4_824 fb824 0 21813.9251
Rl824 out824 0 10
Vr825 ref825 0 0.595528668
E825 out825 0 ref825 fb825 1e6
R3_825 out825 fb825 99850.1614
R4_825 fb825 0 22037.1669
Rl825 out825 0 10
Vr826 ref826 0 0.596854284
E826 out826 0 ref826 fb826 1e6
R3_826 out826 fb826 100640.794
R4_826 fb826 0 21936.4292
Rl826 out826 0 10
Vr827 ref827 0 0.602738929
E827 out827 0 ref827 fb827 1e6
R3_827 out827 fb827 99844.072
R4_827 fb827 0 21941.8994
Rl827 out827 0 10
Vr828 ref828 0 0.593516469
E828 out828 0 ref828 fb828 1e6
R3_828 out828 fb828 99541.1939
R4_828 fb828 0 22187.711
Rl828 out828 0 10
Vr829 ref829 0 0.60455404
E829 out829 0 ref829 fb829 1e6
R3_829 out829 fb829 99999.4947
R4_829 fb829 0 21815.2235
Rl829 out829 0 10
Vr830 ref830 0 0.596092723
E830 out830 0 ref830 fb830 1e6
R3_830 out830 fb830 99367.7575
R4_830 fb830 0 21805.9458
Rl830 out830 0 10
Vr831 ref831 0 0.590187861
E831 out831 0 ref831 fb831 1e6
R3_831 out831 fb831 100380.552
R4_831 fb831 0 22081.7044
Rl831 out831 0 10
Vr832 ref832 0 0.600102932
E832 out832 0 ref832 fb832 1e6
R3_832 out832 fb832 99967.9151
R4_832 fb832 0 22206.4934
Rl832 out832 0 10
Vr833 ref833 0 0.590924137
E833 out833 0 ref833 fb833 1e6
R3_833 out833 fb833 99306.2678
R4_833 fb833 0 22168.0032
Rl833 out833 0 10
Vr834 ref834 0 0.597042076
E834 out834 0 ref834 fb834 1e6
R3_834 out834 fb834 99033.2085
R4_834 fb834 0 21971.7276
Rl834 out834 0 10
Vr835 ref835 0 0.593951136
E835 out835 0 ref835 fb835 1e6
R3_835 out835 fb835 99283.5101
R4_835 fb835 0 22067.1413
Rl835 out835 0 10
Vr836 ref836 0 0.598143811
E836 out836 0 ref836 fb836 1e6
R3_836 out836 fb836 99131.2607
R4_836 fb836 0 21909.4134
Rl836 out836 0 10
Vr837 ref837 0 0.592806066
E837 out837 0 ref837 fb837 1e6
R3_837 out837 fb837 100903
R4_837 fb837 0 22008.6725
Rl837 out837 0 10
Vr838 ref838 0 0.600754511
E838 out838 0 ref838 fb838 1e6
R3_838 out838 fb838 99312.9457
R4_838 fb838 0 21900.4665
Rl838 out838 0 10
Vr839 ref839 0 0.5962807
E839 out839 0 ref839 fb839 1e6
R3_839 out839 fb839 100917.319
R4_839 fb839 0 21861.4125
Rl839 out839 0 10
Vr840 ref840 0 0.589115532
E840 out840 0 ref840 fb840 1e6
R3_840 out840 fb840 99581.2968
R4_840 fb840 0 21799.7627
Rl840 out840 0 10
Vr841 ref841 0 0.590546161
E841 out841 0 ref841 fb841 1e6
R3_841 out841 fb841 99337.0925
R4_841 fb841 0 22048.3641
Rl841 out841 0 10
Vr842 ref842 0 0.608479862
E842 out842 0 ref842 fb842 1e6
R3_842 out842 fb842 99830.6704
R4_842 fb842 0 21814.7824
Rl842 out842 0 10
Vr843 ref843 0 0.601929366
E843 out843 0 ref843 fb843 1e6
R3_843 out843 fb843 100078.025
R4_843 fb843 0 22147.0756
Rl843 out843 0 10
Vr844 ref844 0 0.604175181
E844 out844 0 ref844 fb844 1e6
R3_844 out844 fb844 100046.791
R4_844 fb844 0 21811.5552
Rl844 out844 0 10
Vr845 ref845 0 0.605258315
E845 out845 0 ref845 fb845 1e6
R3_845 out845 fb845 100673.415
R4_845 fb845 0 21899.5044
Rl845 out845 0 10
Vr846 ref846 0 0.6104341
E846 out846 0 ref846 fb846 1e6
R3_846 out846 fb846 99327.7751
R4_846 fb846 0 22148.7186
Rl846 out846 0 10
Vr847 ref847 0 0.600003009
E847 out847 0 ref847 fb847 1e6
R3_847 out847 fb847 99779.2141
R4_847 fb847 0 22048.6375
Rl847 out847 0 10
Vr848 ref848 0 0.593166839
E848 out848 0 ref848 fb848 1e6
R3_848 out848 fb848 99612.8233
R4_848 fb848 0 21946.3842
Rl848 out848 0 10
Vr849 ref849 0 0.603736887
E849 out849 0 ref849 fb849 1e6
R3_849 out849 fb849 99172.841
R4_849 fb849 0 21795.3166
Rl849 out849 0 10
Vr850 ref850 0 0.59804908
E850 out850 0 ref850 fb850 1e6
R3_850 out850 fb850 99918.2231
R4_850 fb850 0 22043.985
Rl850 out850 0 10
Vr851 ref851 0 0.599339484
E851 out851 0 ref851 fb851 1e6
R3_851 out851 fb851 100780.135
R4_851 fb851 0 21966.4387
Rl851 out851 0 10
Vr852 ref852 0 0.594200199
E852 out852 0 ref852 fb852 1e6
R3_852 out852 fb852 100864.782
R4_852 fb852 0 21927.996
Rl852 out852 0 10
Vr853 ref853 0 0.600993862
E853 out853 0 ref853 fb853 1e6
R3_853 out853 fb853 100821.965
R4_853 fb853 0 22068.0728
Rl853 out853 0 10
Vr854 ref854 0 0.594142012
E854 out854 0 ref854 fb854 1e6
R3_854 out854 fb854 100124.367
R4_854 fb854 0 21835.8993
Rl854 out854 0 10
Vr855 ref855 0 0.608417283
E855 out855 0 ref855 fb855 1e6
R3_855 out855 fb855 99895.3421
R4_855 fb855 0 22000.2644
Rl855 out855 0 10
Vr856 ref856 0 0.599513115
E856 out856 0 ref856 fb856 1e6
R3_856 out856 fb856 99119.1494
R4_856 fb856 0 21818.8488
Rl856 out856 0 10
Vr857 ref857 0 0.59804915
E857 out857 0 ref857 fb857 1e6
R3_857 out857 fb857 100098.354
R4_857 fb857 0 21853.6324
Rl857 out857 0 10
Vr858 ref858 0 0.602512311
E858 out858 0 ref858 fb858 1e6
R3_858 out858 fb858 100199.62
R4_858 fb858 0 22065.1432
Rl858 out858 0 10
Vr859 ref859 0 0.600118288
E859 out859 0 ref859 fb859 1e6
R3_859 out859 fb859 100658.31
R4_859 fb859 0 21840.9652
Rl859 out859 0 10
Vr860 ref860 0 0.610903672
E860 out860 0 ref860 fb860 1e6
R3_860 out860 fb860 99416.7484
R4_860 fb860 0 21962.6651
Rl860 out860 0 10
Vr861 ref861 0 0.604056033
E861 out861 0 ref861 fb861 1e6
R3_861 out861 fb861 100548.627
R4_861 fb861 0 22059.2135
Rl861 out861 0 10
Vr862 ref862 0 0.591249661
E862 out862 0 ref862 fb862 1e6
R3_862 out862 fb862 99828.6352
R4_862 fb862 0 22120.1846
Rl862 out862 0 10
Vr863 ref863 0 0.601626429
E863 out863 0 ref863 fb863 1e6
R3_863 out863 fb863 99733.2234
R4_863 fb863 0 21861.766
Rl863 out863 0 10
Vr864 ref864 0 0.602628042
E864 out864 0 ref864 fb864 1e6
R3_864 out864 fb864 100604.922
R4_864 fb864 0 22163.9297
Rl864 out864 0 10
Vr865 ref865 0 0.599177265
E865 out865 0 ref865 fb865 1e6
R3_865 out865 fb865 99907.8251
R4_865 fb865 0 21850.0733
Rl865 out865 0 10
Vr866 ref866 0 0.610818427
E866 out866 0 ref866 fb866 1e6
R3_866 out866 fb866 100711.572
R4_866 fb866 0 21822.5272
Rl866 out866 0 10
Vr867 ref867 0 0.602083485
E867 out867 0 ref867 fb867 1e6
R3_867 out867 fb867 100453.22
R4_867 fb867 0 22140.9832
Rl867 out867 0 10
Vr868 ref868 0 0.592861651
E868 out868 0 ref868 fb868 1e6
R3_868 out868 fb868 100018.148
R4_868 fb868 0 21799.3489
Rl868 out868 0 10
Vr869 ref869 0 0.59797382
E869 out869 0 ref869 fb869 1e6
R3_869 out869 fb869 100023.018
R4_869 fb869 0 21970.7642
Rl869 out869 0 10
Vr870 ref870 0 0.589335848
E870 out870 0 ref870 fb870 1e6
R3_870 out870 fb870 100107.655
R4_870 fb870 0 22188.2741
Rl870 out870 0 10
Vr871 ref871 0 0.598930618
E871 out871 0 ref871 fb871 1e6
R3_871 out871 fb871 100476.716
R4_871 fb871 0 21916.9749
Rl871 out871 0 10
Vr872 ref872 0 0.605999765
E872 out872 0 ref872 fb872 1e6
R3_872 out872 fb872 100820.317
R4_872 fb872 0 22023.7489
Rl872 out872 0 10
Vr873 ref873 0 0.599443026
E873 out873 0 ref873 fb873 1e6
R3_873 out873 fb873 100631.926
R4_873 fb873 0 21867.1549
Rl873 out873 0 10
Vr874 ref874 0 0.610982775
E874 out874 0 ref874 fb874 1e6
R3_874 out874 fb874 100194.96
R4_874 fb874 0 21990.1525
Rl874 out874 0 10
Vr875 ref875 0 0.605836476
E875 out875 0 ref875 fb875 1e6
R3_875 out875 fb875 99924.1581
R4_875 fb875 0 22094.6041
Rl875 out875 0 10
Vr876 ref876 0 0.588676404
E876 out876 0 ref876 fb876 1e6
R3_876 out876 fb876 99076.5221
R4_876 fb876 0 21962.5536
Rl876 out876 0 10
Vr877 ref877 0 0.603526134
E877 out877 0 ref877 fb877 1e6
R3_877 out877 fb877 99631.5703
R4_877 fb877 0 21842.2839
Rl877 out877 0 10
Vr878 ref878 0 0.588092236
E878 out878 0 ref878 fb878 1e6
R3_878 out878 fb878 100447.46
R4_878 fb878 0 22092.337
Rl878 out878 0 10
Vr879 ref879 0 0.59601553
E879 out879 0 ref879 fb879 1e6
R3_879 out879 fb879 100179.201
R4_879 fb879 0 21970.5298
Rl879 out879 0 10
Vr880 ref880 0 0.606331928
E880 out880 0 ref880 fb880 1e6
R3_880 out880 fb880 99277.5077
R4_880 fb880 0 21986.9189
Rl880 out880 0 10
Vr881 ref881 0 0.610623995
E881 out881 0 ref881 fb881 1e6
R3_881 out881 fb881 100225.012
R4_881 fb881 0 21931.5878
Rl881 out881 0 10
Vr882 ref882 0 0.58981432
E882 out882 0 ref882 fb882 1e6
R3_882 out882 fb882 100757.91
R4_882 fb882 0 21811.8584
Rl882 out882 0 10
Vr883 ref883 0 0.589912865
E883 out883 0 ref883 fb883 1e6
R3_883 out883 fb883 100833.84
R4_883 fb883 0 22051.2843
Rl883 out883 0 10
Vr884 ref884 0 0.595626012
E884 out884 0 ref884 fb884 1e6
R3_884 out884 fb884 100458.08
R4_884 fb884 0 21847.489
Rl884 out884 0 10
Vr885 ref885 0 0.600926986
E885 out885 0 ref885 fb885 1e6
R3_885 out885 fb885 99920.9566
R4_885 fb885 0 21974.5394
Rl885 out885 0 10
Vr886 ref886 0 0.598302396
E886 out886 0 ref886 fb886 1e6
R3_886 out886 fb886 99709.982
R4_886 fb886 0 21783.9581
Rl886 out886 0 10
Vr887 ref887 0 0.607467874
E887 out887 0 ref887 fb887 1e6
R3_887 out887 fb887 100573.929
R4_887 fb887 0 22161.5307
Rl887 out887 0 10
Vr888 ref888 0 0.608482113
E888 out888 0 ref888 fb888 1e6
R3_888 out888 fb888 99756.6662
R4_888 fb888 0 22175.6167
Rl888 out888 0 10
Vr889 ref889 0 0.599992375
E889 out889 0 ref889 fb889 1e6
R3_889 out889 fb889 100279.203
R4_889 fb889 0 22191.8822
Rl889 out889 0 10
Vr890 ref890 0 0.589137757
E890 out890 0 ref890 fb890 1e6
R3_890 out890 fb890 100563.431
R4_890 fb890 0 22092.3411
Rl890 out890 0 10
Vr891 ref891 0 0.611928964
E891 out891 0 ref891 fb891 1e6
R3_891 out891 fb891 99274.3576
R4_891 fb891 0 22172.357
Rl891 out891 0 10
Vr892 ref892 0 0.591594472
E892 out892 0 ref892 fb892 1e6
R3_892 out892 fb892 100381.901
R4_892 fb892 0 21799.1258
Rl892 out892 0 10
Vr893 ref893 0 0.602456457
E893 out893 0 ref893 fb893 1e6
R3_893 out893 fb893 99983.222
R4_893 fb893 0 22177.6705
Rl893 out893 0 10
Vr894 ref894 0 0.599031256
E894 out894 0 ref894 fb894 1e6
R3_894 out894 fb894 100911.835
R4_894 fb894 0 21953.8023
Rl894 out894 0 10
Vr895 ref895 0 0.599856686
E895 out895 0 ref895 fb895 1e6
R3_895 out895 fb895 100727.664
R4_895 fb895 0 22113.3484
Rl895 out895 0 10
Vr896 ref896 0 0.595642573
E896 out896 0 ref896 fb896 1e6
R3_896 out896 fb896 100849.845
R4_896 fb896 0 21785.2004
Rl896 out896 0 10
Vr897 ref897 0 0.604473547
E897 out897 0 ref897 fb897 1e6
R3_897 out897 fb897 99725.3447
R4_897 fb897 0 22120.1167
Rl897 out897 0 10
Vr898 ref898 0 0.609283454
E898 out898 0 ref898 fb898 1e6
R3_898 out898 fb898 100212.943
R4_898 fb898 0 22154.2158
Rl898 out898 0 10
Vr899 ref899 0 0.588453517
E899 out899 0 ref899 fb899 1e6
R3_899 out899 fb899 100101.429
R4_899 fb899 0 21955.2086
Rl899 out899 0 10
Vr900 ref900 0 0.608786744
E900 out900 0 ref900 fb900 1e6
R3_900 out900 fb900 99043.946
R4_900 fb900 0 22119.1474
Rl900 out900 0 10
Vr901 ref901 0 0.604241088
E901 out901 0 ref901 fb901 1e6
R3_901 out901 fb901 100326.904
R4_901 fb901 0 21833.5249
Rl901 out901 0 10
Vr902 ref902 0 0.596660697
E902 out902 0 ref902 fb902 1e6
R3_902 out902 fb902 99512.9203
R4_902 fb902 0 21934.855
Rl902 out902 0 10
Vr903 ref903 0 0.602312295
E903 out903 0 ref903 fb903 1e6
R3_903 out903 fb903 100818.716
R4_903 fb903 0 21937.8401
Rl903 out903 0 10
Vr904 ref904 0 0.601497974
E904 out904 0 ref904 fb904 1e6
R3_904 out904 fb904 99846.2161
R4_904 fb904 0 22047.7798
Rl904 out904 0 10
Vr905 ref905 0 0.600510896
E905 out905 0 ref905 fb905 1e6
R3_905 out905 fb905 99101.9118
R4_905 fb905 0 22069.8916
Rl905 out905 0 10
Vr906 ref906 0 0.602682342
E906 out906 0 ref906 fb906 1e6
R3_906 out906 fb906 99631.7941
R4_906 fb906 0 22194.6659
Rl906 out906 0 10
Vr907 ref907 0 0.591600955
E907 out907 0 ref907 fb907 1e6
R3_907 out907 fb907 100761.383
R4_907 fb907 0 22112.5157
Rl907 out907 0 10
Vr908 ref908 0 0.601596857
E908 out908 0 ref908 fb908 1e6
R3_908 out908 fb908 100553.94
R4_908 fb908 0 22122.367
Rl908 out908 0 10
Vr909 ref909 0 0.593686111
E909 out909 0 ref909 fb909 1e6
R3_909 out909 fb909 99675.0351
R4_909 fb909 0 21887.8928
Rl909 out909 0 10
Vr910 ref910 0 0.596616282
E910 out910 0 ref910 fb910 1e6
R3_910 out910 fb910 99605.2968
R4_910 fb910 0 22069.9952
Rl910 out910 0 10
Vr911 ref911 0 0.607913393
E911 out911 0 ref911 fb911 1e6
R3_911 out911 fb911 99942.8198
R4_911 fb911 0 22150.0026
Rl911 out911 0 10
Vr912 ref912 0 0.597517584
E912 out912 0 ref912 fb912 1e6
R3_912 out912 fb912 99693.1897
R4_912 fb912 0 21921.605
Rl912 out912 0 10
Vr913 ref913 0 0.598529505
E913 out913 0 ref913 fb913 1e6
R3_913 out913 fb913 99499.0689
R4_913 fb913 0 22087.9052
Rl913 out913 0 10
Vr914 ref914 0 0.593709531
E914 out914 0 ref914 fb914 1e6
R3_914 out914 fb914 99504.0067
R4_914 fb914 0 22216.0095
Rl914 out914 0 10
Vr915 ref915 0 0.590317653
E915 out915 0 ref915 fb915 1e6
R3_915 out915 fb915 100248.718
R4_915 fb915 0 22162.2586
Rl915 out915 0 10
Vr916 ref916 0 0.591033537
E916 out916 0 ref916 fb916 1e6
R3_916 out916 fb916 100850.602
R4_916 fb916 0 21985.7
Rl916 out916 0 10
Vr917 ref917 0 0.595718611
E917 out917 0 ref917 fb917 1e6
R3_917 out917 fb917 100599.962
R4_917 fb917 0 22108.2139
Rl917 out917 0 10
Vr918 ref918 0 0.604765713
E918 out918 0 ref918 fb918 1e6
R3_918 out918 fb918 100215.631
R4_918 fb918 0 22091.3058
Rl918 out918 0 10
Vr919 ref919 0 0.604787676
E919 out919 0 ref919 fb919 1e6
R3_919 out919 fb919 99237.8407
R4_919 fb919 0 22040.9243
Rl919 out919 0 10
Vr920 ref920 0 0.59279754
E920 out920 0 ref920 fb920 1e6
R3_920 out920 fb920 99381.499
R4_920 fb920 0 21945.2213
Rl920 out920 0 10
Vr921 ref921 0 0.592691283
E921 out921 0 ref921 fb921 1e6
R3_921 out921 fb921 99492.8338
R4_921 fb921 0 22114.3307
Rl921 out921 0 10
Vr922 ref922 0 0.601852021
E922 out922 0 ref922 fb922 1e6
R3_922 out922 fb922 100741.549
R4_922 fb922 0 22028.3298
Rl922 out922 0 10
Vr923 ref923 0 0.590414317
E923 out923 0 ref923 fb923 1e6
R3_923 out923 fb923 100034.491
R4_923 fb923 0 21885.1065
Rl923 out923 0 10
Vr924 ref924 0 0.601853629
E924 out924 0 ref924 fb924 1e6
R3_924 out924 fb924 100120.716
R4_924 fb924 0 22061.6601
Rl924 out924 0 10
Vr925 ref925 0 0.60979113
E925 out925 0 ref925 fb925 1e6
R3_925 out925 fb925 99662.9192
R4_925 fb925 0 22213.8698
Rl925 out925 0 10
Vr926 ref926 0 0.605930158
E926 out926 0 ref926 fb926 1e6
R3_926 out926 fb926 99126.0047
R4_926 fb926 0 22208.9225
Rl926 out926 0 10
Vr927 ref927 0 0.607313595
E927 out927 0 ref927 fb927 1e6
R3_927 out927 fb927 99727.8631
R4_927 fb927 0 21978.5788
Rl927 out927 0 10
Vr928 ref928 0 0.594892582
E928 out928 0 ref928 fb928 1e6
R3_928 out928 fb928 99889.9714
R4_928 fb928 0 22016.2476
Rl928 out928 0 10
Vr929 ref929 0 0.594097672
E929 out929 0 ref929 fb929 1e6
R3_929 out929 fb929 100334.129
R4_929 fb929 0 21988.5981
Rl929 out929 0 10
Vr930 ref930 0 0.609556351
E930 out930 0 ref930 fb930 1e6
R3_930 out930 fb930 99396.5307
R4_930 fb930 0 22184.8178
Rl930 out930 0 10
Vr931 ref931 0 0.606794138
E931 out931 0 ref931 fb931 1e6
R3_931 out931 fb931 99416.6731
R4_931 fb931 0 21833.8678
Rl931 out931 0 10
Vr932 ref932 0 0.596854046
E932 out932 0 ref932 fb932 1e6
R3_932 out932 fb932 100404.43
R4_932 fb932 0 21928.3872
Rl932 out932 0 10
Vr933 ref933 0 0.604625999
E933 out933 0 ref933 fb933 1e6
R3_933 out933 fb933 99134.6507
R4_933 fb933 0 21824.974
Rl933 out933 0 10
Vr934 ref934 0 0.608415634
E934 out934 0 ref934 fb934 1e6
R3_934 out934 fb934 99105.0885
R4_934 fb934 0 22029.8818
Rl934 out934 0 10
Vr935 ref935 0 0.610952744
E935 out935 0 ref935 fb935 1e6
R3_935 out935 fb935 99936.777
R4_935 fb935 0 22200.6744
Rl935 out935 0 10
Vr936 ref936 0 0.605283853
E936 out936 0 ref936 fb936 1e6
R3_936 out936 fb936 100554.144
R4_936 fb936 0 22188.0862
Rl936 out936 0 10
Vr937 ref937 0 0.610424746
E937 out937 0 ref937 fb937 1e6
R3_937 out937 fb937 99949.1029
R4_937 fb937 0 21913.1898
Rl937 out937 0 10
Vr938 ref938 0 0.610796491
E938 out938 0 ref938 fb938 1e6
R3_938 out938 fb938 100653.064
R4_938 fb938 0 21880.7362
Rl938 out938 0 10
Vr939 ref939 0 0.592027888
E939 out939 0 ref939 fb939 1e6
R3_939 out939 fb939 100209.822
R4_939 fb939 0 21962.9308
Rl939 out939 0 10
Vr940 ref940 0 0.592299859
E940 out940 0 ref940 fb940 1e6
R3_940 out940 fb940 100200.684
R4_940 fb940 0 22055.6414
Rl940 out940 0 10
Vr941 ref941 0 0.610341949
E941 out941 0 ref941 fb941 1e6
R3_941 out941 fb941 99938.3481
R4_941 fb941 0 21830.5196
Rl941 out941 0 10
Vr942 ref942 0 0.604640447
E942 out942 0 ref942 fb942 1e6
R3_942 out942 fb942 100290.844
R4_942 fb942 0 22088.3016
Rl942 out942 0 10
Vr943 ref943 0 0.607660812
E943 out943 0 ref943 fb943 1e6
R3_943 out943 fb943 99312.9012
R4_943 fb943 0 22058.5717
Rl943 out943 0 10
Vr944 ref944 0 0.598764913
E944 out944 0 ref944 fb944 1e6
R3_944 out944 fb944 99448.7996
R4_944 fb944 0 21818.6328
Rl944 out944 0 10
Vr945 ref945 0 0.608742585
E945 out945 0 ref945 fb945 1e6
R3_945 out945 fb945 99824.006
R4_945 fb945 0 22098.3108
Rl945 out945 0 10
Vr946 ref946 0 0.598834087
E946 out946 0 ref946 fb946 1e6
R3_946 out946 fb946 99934.1064
R4_946 fb946 0 21940.9256
Rl946 out946 0 10
Vr947 ref947 0 0.610131824
E947 out947 0 ref947 fb947 1e6
R3_947 out947 fb947 100483.088
R4_947 fb947 0 22095.5089
Rl947 out947 0 10
Vr948 ref948 0 0.610061403
E948 out948 0 ref948 fb948 1e6
R3_948 out948 fb948 100366.19
R4_948 fb948 0 21798.8143
Rl948 out948 0 10
Vr949 ref949 0 0.605339832
E949 out949 0 ref949 fb949 1e6
R3_949 out949 fb949 99506.7613
R4_949 fb949 0 22186.4553
Rl949 out949 0 10
Vr950 ref950 0 0.610322581
E950 out950 0 ref950 fb950 1e6
R3_950 out950 fb950 100087.149
R4_950 fb950 0 21972.6465
Rl950 out950 0 10
Vr951 ref951 0 0.596497106
E951 out951 0 ref951 fb951 1e6
R3_951 out951 fb951 100208.245
R4_951 fb951 0 21879.7756
Rl951 out951 0 10
Vr952 ref952 0 0.606037904
E952 out952 0 ref952 fb952 1e6
R3_952 out952 fb952 99357.2368
R4_952 fb952 0 22010.3554
Rl952 out952 0 10
Vr953 ref953 0 0.588538397
E953 out953 0 ref953 fb953 1e6
R3_953 out953 fb953 99757.2089
R4_953 fb953 0 22134.2276
Rl953 out953 0 10
Vr954 ref954 0 0.604312727
E954 out954 0 ref954 fb954 1e6
R3_954 out954 fb954 100692.029
R4_954 fb954 0 22185.2667
Rl954 out954 0 10
Vr955 ref955 0 0.603878697
E955 out955 0 ref955 fb955 1e6
R3_955 out955 fb955 100116.739
R4_955 fb955 0 21888.8605
Rl955 out955 0 10
Vr956 ref956 0 0.609447881
E956 out956 0 ref956 fb956 1e6
R3_956 out956 fb956 99602.9728
R4_956 fb956 0 21871.3037
Rl956 out956 0 10
Vr957 ref957 0 0.592968716
E957 out957 0 ref957 fb957 1e6
R3_957 out957 fb957 100627.338
R4_957 fb957 0 21878.0819
Rl957 out957 0 10
Vr958 ref958 0 0.589843869
E958 out958 0 ref958 fb958 1e6
R3_958 out958 fb958 100536.638
R4_958 fb958 0 22217.8522
Rl958 out958 0 10
Vr959 ref959 0 0.600523689
E959 out959 0 ref959 fb959 1e6
R3_959 out959 fb959 100976.193
R4_959 fb959 0 22153.6052
Rl959 out959 0 10
Vr960 ref960 0 0.606902918
E960 out960 0 ref960 fb960 1e6
R3_960 out960 fb960 100295.359
R4_960 fb960 0 22038.0098
Rl960 out960 0 10
Vr961 ref961 0 0.608620438
E961 out961 0 ref961 fb961 1e6
R3_961 out961 fb961 100836.478
R4_961 fb961 0 22063.9319
Rl961 out961 0 10
Vr962 ref962 0 0.589566696
E962 out962 0 ref962 fb962 1e6
R3_962 out962 fb962 99317.8103
R4_962 fb962 0 22026.0071
Rl962 out962 0 10
Vr963 ref963 0 0.592283261
E963 out963 0 ref963 fb963 1e6
R3_963 out963 fb963 100987.36
R4_963 fb963 0 21850.4145
Rl963 out963 0 10
Vr964 ref964 0 0.608040054
E964 out964 0 ref964 fb964 1e6
R3_964 out964 fb964 100838.558
R4_964 fb964 0 21808.9817
Rl964 out964 0 10
Vr965 ref965 0 0.591352145
E965 out965 0 ref965 fb965 1e6
R3_965 out965 fb965 99017.4495
R4_965 fb965 0 21881.1098
Rl965 out965 0 10
Vr966 ref966 0 0.588352281
E966 out966 0 ref966 fb966 1e6
R3_966 out966 fb966 100655.478
R4_966 fb966 0 22151.4197
Rl966 out966 0 10
Vr967 ref967 0 0.592482489
E967 out967 0 ref967 fb967 1e6
R3_967 out967 fb967 99421.1619
R4_967 fb967 0 21891.2859
Rl967 out967 0 10
Vr968 ref968 0 0.610359595
E968 out968 0 ref968 fb968 1e6
R3_968 out968 fb968 100813.672
R4_968 fb968 0 21845.8575
Rl968 out968 0 10
Vr969 ref969 0 0.596534043
E969 out969 0 ref969 fb969 1e6
R3_969 out969 fb969 100537.421
R4_969 fb969 0 22008.1309
Rl969 out969 0 10
Vr970 ref970 0 0.611460373
E970 out970 0 ref970 fb970 1e6
R3_970 out970 fb970 99243.5139
R4_970 fb970 0 21898.5588
Rl970 out970 0 10
Vr971 ref971 0 0.602196526
E971 out971 0 ref971 fb971 1e6
R3_971 out971 fb971 99225.2912
R4_971 fb971 0 22164.6864
Rl971 out971 0 10
Vr972 ref972 0 0.604820292
E972 out972 0 ref972 fb972 1e6
R3_972 out972 fb972 100725.164
R4_972 fb972 0 21812.1758
Rl972 out972 0 10
Vr973 ref973 0 0.589965765
E973 out973 0 ref973 fb973 1e6
R3_973 out973 fb973 100176.254
R4_973 fb973 0 22142.6698
Rl973 out973 0 10
Vr974 ref974 0 0.596588427
E974 out974 0 ref974 fb974 1e6
R3_974 out974 fb974 100939.452
R4_974 fb974 0 22172.6231
Rl974 out974 0 10
Vr975 ref975 0 0.596936029
E975 out975 0 ref975 fb975 1e6
R3_975 out975 fb975 99332.0367
R4_975 fb975 0 22127.2454
Rl975 out975 0 10
Vr976 ref976 0 0.588983683
E976 out976 0 ref976 fb976 1e6
R3_976 out976 fb976 99247.7417
R4_976 fb976 0 22199.7055
Rl976 out976 0 10
Vr977 ref977 0 0.591553915
E977 out977 0 ref977 fb977 1e6
R3_977 out977 fb977 99930.4904
R4_977 fb977 0 21975.5841
Rl977 out977 0 10
Vr978 ref978 0 0.593449891
E978 out978 0 ref978 fb978 1e6
R3_978 out978 fb978 99804.5625
R4_978 fb978 0 22029.7205
Rl978 out978 0 10
Vr979 ref979 0 0.595230265
E979 out979 0 ref979 fb979 1e6
R3_979 out979 fb979 100021.654
R4_979 fb979 0 21830.8031
Rl979 out979 0 10
Vr980 ref980 0 0.597254084
E980 out980 0 ref980 fb980 1e6
R3_980 out980 fb980 99337.8693
R4_980 fb980 0 21857.0232
Rl980 out980 0 10
Vr981 ref981 0 0.592282561
E981 out981 0 ref981 fb981 1e6
R3_981 out981 fb981 100142.38
R4_981 fb981 0 21937.1726
Rl981 out981 0 10
Vr982 ref982 0 0.589636596
E982 out982 0 ref982 fb982 1e6
R3_982 out982 fb982 99739.1317
R4_982 fb982 0 21850.1982
Rl982 out982 0 10
Vr983 ref983 0 0.607011113
E983 out983 0 ref983 fb983 1e6
R3_983 out983 fb983 99006.4671
R4_983 fb983 0 22080.6956
Rl983 out983 0 10
Vr984 ref984 0 0.597789405
E984 out984 0 ref984 fb984 1e6
R3_984 out984 fb984 99736.2358
R4_984 fb984 0 22072.0888
Rl984 out984 0 10
Vr985 ref985 0 0.594973714
E985 out985 0 ref985 fb985 1e6
R3_985 out985 fb985 100584.416
R4_985 fb985 0 22094.4203
Rl985 out985 0 10
Vr986 ref986 0 0.599800634
E986 out986 0 ref986 fb986 1e6
R3_986 out986 fb986 100279.161
R4_986 fb986 0 22053.7021
Rl986 out986 0 10
Vr987 ref987 0 0.592352154
E987 out987 0 ref987 fb987 1e6
R3_987 out987 fb987 99522.4787
R4_987 fb987 0 21989.1025
Rl987 out987 0 10
Vr988 ref988 0 0.593141535
E988 out988 0 ref988 fb988 1e6
R3_988 out988 fb988 99978.4733
R4_988 fb988 0 21980.2019
Rl988 out988 0 10
Vr989 ref989 0 0.603802531
E989 out989 0 ref989 fb989 1e6
R3_989 out989 fb989 99531.5357
R4_989 fb989 0 22094.9214
Rl989 out989 0 10
Vr990 ref990 0 0.592814283
E990 out990 0 ref990 fb990 1e6
R3_990 out990 fb990 99591.4468
R4_990 fb990 0 22013.5912
Rl990 out990 0 10
Vr991 ref991 0 0.596959746
E991 out991 0 ref991 fb991 1e6
R3_991 out991 fb991 99677.0777
R4_991 fb991 0 22219.5696
Rl991 out991 0 10
Vr992 ref992 0 0.610135838
E992 out992 0 ref992 fb992 1e6
R3_992 out992 fb992 100852.121
R4_992 fb992 0 21945.8429
Rl992 out992 0 10
Vr993 ref993 0 0.59462507
E993 out993 0 ref993 fb993 1e6
R3_993 out993 fb993 100500.156
R4_993 fb993 0 22191.5506
Rl993 out993 0 10
Vr994 ref994 0 0.604739585
E994 out994 0 ref994 fb994 1e6
R3_994 out994 fb994 100654.324
R4_994 fb994 0 22081.406
Rl994 out994 0 10
Vr995 ref995 0 0.605820235
E995 out995 0 ref995 fb995 1e6
R3_995 out995 fb995 100493.098
R4_995 fb995 0 22206.4088
Rl995 out995 0 10
Vr996 ref996 0 0.599515109
E996 out996 0 ref996 fb996 1e6
R3_996 out996 fb996 100871.174
R4_996 fb996 0 21899.4999
Rl996 out996 0 10
Vr997 ref997 0 0.592986837
E997 out997 0 ref997 fb997 1e6
R3_997 out997 fb997 99939.3694
R4_997 fb997 0 21792.0133
Rl997 out997 0 10
Vr998 ref998 0 0.589961941
E998 out998 0 ref998 fb998 1e6
R3_998 out998 fb998 99996.7237
R4_998 fb998 0 21929.0227
Rl998 out998 0 10
Vr999 ref999 0 0.591691665
E999 out999 0 ref999 fb999 1e6
R3_999 out999 fb999 99500.238
R4_999 fb999 0 22037.1968
Rl999 out999 0 10
Vr1000 ref1000 0 0.601229564
E1000 out1000 0 ref1000 fb1000 1e6
R3_1000 out1000 fb1000 99285.6469
R4_1000 fb1000 0 21899.9437
Rl1000 out1000 0 10
Vr1001 ref1001 0 0.588142048
E1001 out1001 0 ref1001 fb1001 1e6
R3_1001 out1001 fb1001 99131.303
R4_1001 fb1001 0 22062.0678
Rl1001 out1001 0 10
Vr1002 ref1002 0 0.594549761
E1002 out1002 0 ref1002 fb1002 1e6
R3_1002 out1002 fb1002 100711.513
R4_1002 fb1002 0 22100.299
Rl1002 out1002 0 10
Vr1003 ref1003 0 0.590332811
E1003 out1003 0 ref1003 fb1003 1e6
R3_1003 out1003 fb1003 100480.622
R4_1003 fb1003 0 22039.8116
Rl1003 out1003 0 10
Vr1004 ref1004 0 0.606654863
E1004 out1004 0 ref1004 fb1004 1e6
R3_1004 out1004 fb1004 100528.26
R4_1004 fb1004 0 21969.3966
Rl1004 out1004 0 10
Vr1005 ref1005 0 0.596513016
E1005 out1005 0 ref1005 fb1005 1e6
R3_1005 out1005 fb1005 100757.162
R4_1005 fb1005 0 22135.7835
Rl1005 out1005 0 10
Vr1006 ref1006 0 0.611798
E1006 out1006 0 ref1006 fb1006 1e6
R3_1006 out1006 fb1006 100532.221
R4_1006 fb1006 0 21840.616
Rl1006 out1006 0 10
Vr1007 ref1007 0 0.609930895
E1007 out1007 0 ref1007 fb1007 1e6
R3_1007 out1007 fb1007 100340.615
R4_1007 fb1007 0 22099.9796
Rl1007 out1007 0 10
Vr1008 ref1008 0 0.60199008
E1008 out1008 0 ref1008 fb1008 1e6
R3_1008 out1008 fb1008 100790.383
R4_1008 fb1008 0 22048.9362
Rl1008 out1008 0 10
Vr1009 ref1009 0 0.60217416
E1009 out1009 0 ref1009 fb1009 1e6
R3_1009 out1009 fb1009 99482.8568
R4_1009 fb1009 0 22049.927
Rl1009 out1009 0 10
Vr1010 ref1010 0 0.598333938
E1010 out1010 0 ref1010 fb1010 1e6
R3_1010 out1010 fb1010 99679.4995
R4_1010 fb1010 0 21802.7798
Rl1010 out1010 0 10
Vr1011 ref1011 0 0.58887932
E1011 out1011 0 ref1011 fb1011 1e6
R3_1011 out1011 fb1011 100629.681
R4_1011 fb1011 0 21935.373
Rl1011 out1011 0 10
Vr1012 ref1012 0 0.607619009
E1012 out1012 0 ref1012 fb1012 1e6
R3_1012 out1012 fb1012 99650.7128
R4_1012 fb1012 0 21860.4106
Rl1012 out1012 0 10
Vr1013 ref1013 0 0.606936363
E1013 out1013 0 ref1013 fb1013 1e6
R3_1013 out1013 fb1013 100925.163
R4_1013 fb1013 0 21796.2635
Rl1013 out1013 0 10
Vr1014 ref1014 0 0.598234187
E1014 out1014 0 ref1014 fb1014 1e6
R3_1014 out1014 fb1014 99072.5407
R4_1014 fb1014 0 22077.3491
Rl1014 out1014 0 10
Vr1015 ref1015 0 0.592019212
E1015 out1015 0 ref1015 fb1015 1e6
R3_1015 out1015 fb1015 100395.882
R4_1015 fb1015 0 21947.5692
Rl1015 out1015 0 10
Vr1016 ref1016 0 0.604291153
E1016 out1016 0 ref1016 fb1016 1e6
R3_1016 out1016 fb1016 100039.076
R4_1016 fb1016 0 21891.4359
Rl1016 out1016 0 10
Vr1017 ref1017 0 0.607153808
E1017 out1017 0 ref1017 fb1017 1e6
R3_1017 out1017 fb1017 100644.38
R4_1017 fb1017 0 22095.2606
Rl1017 out1017 0 10
Vr1018 ref1018 0 0.607239909
E1018 out1018 0 ref1018 fb1018 1e6
R3_1018 out1018 fb1018 100921.938
R4_1018 fb1018 0 22069.5611
Rl1018 out1018 0 10
Vr1019 ref1019 0 0.601541413
E1019 out1019 0 ref1019 fb1019 1e6
R3_1019 out1019 fb1019 99351.049
R4_1019 fb1019 0 22171.8772
Rl1019 out1019 0 10
Vr1020 ref1020 0 0.591999832
E1020 out1020 0 ref1020 fb1020 1e6
R3_1020 out1020 fb1020 100572.061
R4_1020 fb1020 0 22013.3955
Rl1020 out1020 0 10
Vr1021 ref1021 0 0.60697215
E1021 out1021 0 ref1021 fb1021 1e6
R3_1021 out1021 fb1021 100513.104
R4_1021 fb1021 0 22079.7001
Rl1021 out1021 0 10
Vr1022 ref1022 0 0.61193814
E1022 out1022 0 ref1022 fb1022 1e6
R3_1022 out1022 fb1022 99148.6094
R4_1022 fb1022 0 22107.7364
Rl1022 out1022 0 10
Vr1023 ref1023 0 0.598963153
E1023 out1023 0 ref1023 fb1023 1e6
R3_1023 out1023 fb1023 100838.082
R4_1023 fb1023 0 21917.1404
Rl1023 out1023 0 10
Vr1024 ref1024 0 0.605170587
E1024 out1024 0 ref1024 fb1024 1e6
R3_1024 out1024 fb1024 100430.533
R4_1024 fb1024 0 22137.25
Rl1024 out1024 0 10
Vr1025 ref1025 0 0.601699131
E1025 out1025 0 ref1025 fb1025 1e6
R3_1025 out1025 fb1025 100807.782
R4_1025 fb1025 0 22200.1165
Rl1025 out1025 0 10
Vr1026 ref1026 0 0.607837591
E1026 out1026 0 ref1026 fb1026 1e6
R3_1026 out1026 fb1026 100768.871
R4_1026 fb1026 0 21788.8879
Rl1026 out1026 0 10
Vr1027 ref1027 0 0.593134366
E1027 out1027 0 ref1027 fb1027 1e6
R3_1027 out1027 fb1027 99023.3625
R4_1027 fb1027 0 21940.0955
Rl1027 out1027 0 10
Vr1028 ref1028 0 0.605558199
E1028 out1028 0 ref1028 fb1028 1e6
R3_1028 out1028 fb1028 99717.5821
R4_1028 fb1028 0 21816.4714
Rl1028 out1028 0 10
Vr1029 ref1029 0 0.611780447
E1029 out1029 0 ref1029 fb1029 1e6
R3_1029 out1029 fb1029 100932.593
R4_1029 fb1029 0 22081.1029
Rl1029 out1029 0 10
Vr1030 ref1030 0 0.595531255
E1030 out1030 0 ref1030 fb1030 1e6
R3_1030 out1030 fb1030 99414.5388
R4_1030 fb1030 0 22085.2153
Rl1030 out1030 0 10
Vr1031 ref1031 0 0.599693469
E1031 out1031 0 ref1031 fb1031 1e6
R3_1031 out1031 fb1031 100951.845
R4_1031 fb1031 0 22201.3162
Rl1031 out1031 0 10
Vr1032 ref1032 0 0.602058394
E1032 out1032 0 ref1032 fb1032 1e6
R3_1032 out1032 fb1032 100101.067
R4_1032 fb1032 0 21935.6825
Rl1032 out1032 0 10
Vr1033 ref1033 0 0.599686
E1033 out1033 0 ref1033 fb1033 1e6
R3_1033 out1033 fb1033 100400.445
R4_1033 fb1033 0 22165.4048
Rl1033 out1033 0 10
Vr1034 ref1034 0 0.609514185
E1034 out1034 0 ref1034 fb1034 1e6
R3_1034 out1034 fb1034 100333.149
R4_1034 fb1034 0 22157.6858
Rl1034 out1034 0 10
Vr1035 ref1035 0 0.598796824
E1035 out1035 0 ref1035 fb1035 1e6
R3_1035 out1035 fb1035 100738.879
R4_1035 fb1035 0 22129.6152
Rl1035 out1035 0 10
Vr1036 ref1036 0 0.603511462
E1036 out1036 0 ref1036 fb1036 1e6
R3_1036 out1036 fb1036 99159.5366
R4_1036 fb1036 0 21988.0868
Rl1036 out1036 0 10
Vr1037 ref1037 0 0.598572288
E1037 out1037 0 ref1037 fb1037 1e6
R3_1037 out1037 fb1037 99199.4603
R4_1037 fb1037 0 22152.5726
Rl1037 out1037 0 10
Vr1038 ref1038 0 0.604096307
E1038 out1038 0 ref1038 fb1038 1e6
R3_1038 out1038 fb1038 99714.1329
R4_1038 fb1038 0 22203.3805
Rl1038 out1038 0 10
Vr1039 ref1039 0 0.598616665
E1039 out1039 0 ref1039 fb1039 1e6
R3_1039 out1039 fb1039 100067.757
R4_1039 fb1039 0 21822.9194
Rl1039 out1039 0 10
Vr1040 ref1040 0 0.591874024
E1040 out1040 0 ref1040 fb1040 1e6
R3_1040 out1040 fb1040 100391.918
R4_1040 fb1040 0 22058.3079
Rl1040 out1040 0 10
Vr1041 ref1041 0 0.600129811
E1041 out1041 0 ref1041 fb1041 1e6
R3_1041 out1041 fb1041 100127.446
R4_1041 fb1041 0 21975.9624
Rl1041 out1041 0 10
Vr1042 ref1042 0 0.593186084
E1042 out1042 0 ref1042 fb1042 1e6
R3_1042 out1042 fb1042 99280.002
R4_1042 fb1042 0 22085.2006
Rl1042 out1042 0 10
Vr1043 ref1043 0 0.610441942
E1043 out1043 0 ref1043 fb1043 1e6
R3_1043 out1043 fb1043 100613.996
R4_1043 fb1043 0 21960.919
Rl1043 out1043 0 10
Vr1044 ref1044 0 0.602321833
E1044 out1044 0 ref1044 fb1044 1e6
R3_1044 out1044 fb1044 100014.427
R4_1044 fb1044 0 21988.8139
Rl1044 out1044 0 10
Vr1045 ref1045 0 0.600875494
E1045 out1045 0 ref1045 fb1045 1e6
R3_1045 out1045 fb1045 99618.2643
R4_1045 fb1045 0 21782.169
Rl1045 out1045 0 10
Vr1046 ref1046 0 0.60683698
E1046 out1046 0 ref1046 fb1046 1e6
R3_1046 out1046 fb1046 99658.0469
R4_1046 fb1046 0 21868.7881
Rl1046 out1046 0 10
Vr1047 ref1047 0 0.601436281
E1047 out1047 0 ref1047 fb1047 1e6
R3_1047 out1047 fb1047 100789.973
R4_1047 fb1047 0 21921.0011
Rl1047 out1047 0 10
Vr1048 ref1048 0 0.601242948
E1048 out1048 0 ref1048 fb1048 1e6
R3_1048 out1048 fb1048 100484.669
R4_1048 fb1048 0 22035.5004
Rl1048 out1048 0 10
Vr1049 ref1049 0 0.596367685
E1049 out1049 0 ref1049 fb1049 1e6
R3_1049 out1049 fb1049 100429.992
R4_1049 fb1049 0 22076.7015
Rl1049 out1049 0 10
Vr1050 ref1050 0 0.596806183
E1050 out1050 0 ref1050 fb1050 1e6
R3_1050 out1050 fb1050 99949.7133
R4_1050 fb1050 0 22145.3197
Rl1050 out1050 0 10
Vr1051 ref1051 0 0.609932546
E1051 out1051 0 ref1051 fb1051 1e6
R3_1051 out1051 fb1051 100276.167
R4_1051 fb1051 0 21925.3118
Rl1051 out1051 0 10
Vr1052 ref1052 0 0.610246483
E1052 out1052 0 ref1052 fb1052 1e6
R3_1052 out1052 fb1052 99833.0163
R4_1052 fb1052 0 21970.1793
Rl1052 out1052 0 10
Vr1053 ref1053 0 0.608123537
E1053 out1053 0 ref1053 fb1053 1e6
R3_1053 out1053 fb1053 100023.911
R4_1053 fb1053 0 21863.9835
Rl1053 out1053 0 10
Vr1054 ref1054 0 0.591595729
E1054 out1054 0 ref1054 fb1054 1e6
R3_1054 out1054 fb1054 100918.368
R4_1054 fb1054 0 21893.9163
Rl1054 out1054 0 10
Vr1055 ref1055 0 0.611936831
E1055 out1055 0 ref1055 fb1055 1e6
R3_1055 out1055 fb1055 99371.3962
R4_1055 fb1055 0 21838.7596
Rl1055 out1055 0 10
Vr1056 ref1056 0 0.604148851
E1056 out1056 0 ref1056 fb1056 1e6
R3_1056 out1056 fb1056 100892.462
R4_1056 fb1056 0 21827.4646
Rl1056 out1056 0 10
Vr1057 ref1057 0 0.600503708
E1057 out1057 0 ref1057 fb1057 1e6
R3_1057 out1057 fb1057 100683.872
R4_1057 fb1057 0 22205.6698
Rl1057 out1057 0 10
Vr1058 ref1058 0 0.604095991
E1058 out1058 0 ref1058 fb1058 1e6
R3_1058 out1058 fb1058 99296.2392
R4_1058 fb1058 0 22086.6472
Rl1058 out1058 0 10
Vr1059 ref1059 0 0.588652018
E1059 out1059 0 ref1059 fb1059 1e6
R3_1059 out1059 fb1059 99381.5571
R4_1059 fb1059 0 22200.0986
Rl1059 out1059 0 10
Vr1060 ref1060 0 0.597492211
E1060 out1060 0 ref1060 fb1060 1e6
R3_1060 out1060 fb1060 99697.8047
R4_1060 fb1060 0 22133.0009
Rl1060 out1060 0 10
Vr1061 ref1061 0 0.601045012
E1061 out1061 0 ref1061 fb1061 1e6
R3_1061 out1061 fb1061 100870.305
R4_1061 fb1061 0 21841.1319
Rl1061 out1061 0 10
Vr1062 ref1062 0 0.605119088
E1062 out1062 0 ref1062 fb1062 1e6
R3_1062 out1062 fb1062 100564.477
R4_1062 fb1062 0 22122.0652
Rl1062 out1062 0 10
Vr1063 ref1063 0 0.60600391
E1063 out1063 0 ref1063 fb1063 1e6
R3_1063 out1063 fb1063 99990.4634
R4_1063 fb1063 0 22142.8428
Rl1063 out1063 0 10
Vr1064 ref1064 0 0.595295919
E1064 out1064 0 ref1064 fb1064 1e6
R3_1064 out1064 fb1064 99129.408
R4_1064 fb1064 0 22193.2165
Rl1064 out1064 0 10
Vr1065 ref1065 0 0.594188152
E1065 out1065 0 ref1065 fb1065 1e6
R3_1065 out1065 fb1065 99074.8494
R4_1065 fb1065 0 22214.3191
Rl1065 out1065 0 10
Vr1066 ref1066 0 0.609075505
E1066 out1066 0 ref1066 fb1066 1e6
R3_1066 out1066 fb1066 100421.513
R4_1066 fb1066 0 21968.0386
Rl1066 out1066 0 10
Vr1067 ref1067 0 0.589243554
E1067 out1067 0 ref1067 fb1067 1e6
R3_1067 out1067 fb1067 100556.332
R4_1067 fb1067 0 22121.2724
Rl1067 out1067 0 10
Vr1068 ref1068 0 0.606693173
E1068 out1068 0 ref1068 fb1068 1e6
R3_1068 out1068 fb1068 100523.451
R4_1068 fb1068 0 21841.4133
Rl1068 out1068 0 10
Vr1069 ref1069 0 0.611245552
E1069 out1069 0 ref1069 fb1069 1e6
R3_1069 out1069 fb1069 99149.9211
R4_1069 fb1069 0 22200.213
Rl1069 out1069 0 10
Vr1070 ref1070 0 0.593867506
E1070 out1070 0 ref1070 fb1070 1e6
R3_1070 out1070 fb1070 100452.857
R4_1070 fb1070 0 21817.1676
Rl1070 out1070 0 10
Vr1071 ref1071 0 0.593300305
E1071 out1071 0 ref1071 fb1071 1e6
R3_1071 out1071 fb1071 99812.8178
R4_1071 fb1071 0 21791.2204
Rl1071 out1071 0 10
Vr1072 ref1072 0 0.595371986
E1072 out1072 0 ref1072 fb1072 1e6
R3_1072 out1072 fb1072 100862.265
R4_1072 fb1072 0 21811.2328
Rl1072 out1072 0 10
Vr1073 ref1073 0 0.594106148
E1073 out1073 0 ref1073 fb1073 1e6
R3_1073 out1073 fb1073 99300.0424
R4_1073 fb1073 0 22069.1347
Rl1073 out1073 0 10
Vr1074 ref1074 0 0.608439936
E1074 out1074 0 ref1074 fb1074 1e6
R3_1074 out1074 fb1074 99137.6506
R4_1074 fb1074 0 22035.5734
Rl1074 out1074 0 10
Vr1075 ref1075 0 0.610790415
E1075 out1075 0 ref1075 fb1075 1e6
R3_1075 out1075 fb1075 100335.485
R4_1075 fb1075 0 22055.2574
Rl1075 out1075 0 10
Vr1076 ref1076 0 0.594321085
E1076 out1076 0 ref1076 fb1076 1e6
R3_1076 out1076 fb1076 100553.827
R4_1076 fb1076 0 22201.0482
Rl1076 out1076 0 10
Vr1077 ref1077 0 0.595910344
E1077 out1077 0 ref1077 fb1077 1e6
R3_1077 out1077 fb1077 99790.3373
R4_1077 fb1077 0 22041.7443
Rl1077 out1077 0 10
Vr1078 ref1078 0 0.609036917
E1078 out1078 0 ref1078 fb1078 1e6
R3_1078 out1078 fb1078 100736.463
R4_1078 fb1078 0 22122.0024
Rl1078 out1078 0 10
Vr1079 ref1079 0 0.588236264
E1079 out1079 0 ref1079 fb1079 1e6
R3_1079 out1079 fb1079 99914.5434
R4_1079 fb1079 0 21974.8809
Rl1079 out1079 0 10
Vr1080 ref1080 0 0.600075663
E1080 out1080 0 ref1080 fb1080 1e6
R3_1080 out1080 fb1080 99096.2619
R4_1080 fb1080 0 22094.3228
Rl1080 out1080 0 10
Vr1081 ref1081 0 0.590475857
E1081 out1081 0 ref1081 fb1081 1e6
R3_1081 out1081 fb1081 100474.129
R4_1081 fb1081 0 21882.8808
Rl1081 out1081 0 10
Vr1082 ref1082 0 0.610043417
E1082 out1082 0 ref1082 fb1082 1e6
R3_1082 out1082 fb1082 100491.479
R4_1082 fb1082 0 22136.7059
Rl1082 out1082 0 10
Vr1083 ref1083 0 0.608280308
E1083 out1083 0 ref1083 fb1083 1e6
R3_1083 out1083 fb1083 99604.3193
R4_1083 fb1083 0 22204.1871
Rl1083 out1083 0 10
Vr1084 ref1084 0 0.589023228
E1084 out1084 0 ref1084 fb1084 1e6
R3_1084 out1084 fb1084 99835.0562
R4_1084 fb1084 0 21790.8983
Rl1084 out1084 0 10
Vr1085 ref1085 0 0.589238721
E1085 out1085 0 ref1085 fb1085 1e6
R3_1085 out1085 fb1085 99967.5214
R4_1085 fb1085 0 21960.2129
Rl1085 out1085 0 10
Vr1086 ref1086 0 0.601718904
E1086 out1086 0 ref1086 fb1086 1e6
R3_1086 out1086 fb1086 99805.6842
R4_1086 fb1086 0 22103.6976
Rl1086 out1086 0 10
Vr1087 ref1087 0 0.605162468
E1087 out1087 0 ref1087 fb1087 1e6
R3_1087 out1087 fb1087 100442.21
R4_1087 fb1087 0 21870.8525
Rl1087 out1087 0 10
Vr1088 ref1088 0 0.591852572
E1088 out1088 0 ref1088 fb1088 1e6
R3_1088 out1088 fb1088 99156.7123
R4_1088 fb1088 0 22171.1125
Rl1088 out1088 0 10
Vr1089 ref1089 0 0.605714332
E1089 out1089 0 ref1089 fb1089 1e6
R3_1089 out1089 fb1089 99893.8866
R4_1089 fb1089 0 22104.2866
Rl1089 out1089 0 10
Vr1090 ref1090 0 0.605523413
E1090 out1090 0 ref1090 fb1090 1e6
R3_1090 out1090 fb1090 99314.7732
R4_1090 fb1090 0 21984.6702
Rl1090 out1090 0 10
Vr1091 ref1091 0 0.597996207
E1091 out1091 0 ref1091 fb1091 1e6
R3_1091 out1091 fb1091 99314.7607
R4_1091 fb1091 0 21971.5947
Rl1091 out1091 0 10
Vr1092 ref1092 0 0.601587593
E1092 out1092 0 ref1092 fb1092 1e6
R3_1092 out1092 fb1092 99771.7155
R4_1092 fb1092 0 21825.7668
Rl1092 out1092 0 10
Vr1093 ref1093 0 0.600542357
E1093 out1093 0 ref1093 fb1093 1e6
R3_1093 out1093 fb1093 99458.0666
R4_1093 fb1093 0 21870.5574
Rl1093 out1093 0 10
Vr1094 ref1094 0 0.605441863
E1094 out1094 0 ref1094 fb1094 1e6
R3_1094 out1094 fb1094 100586.486
R4_1094 fb1094 0 22119.5863
Rl1094 out1094 0 10
Vr1095 ref1095 0 0.589078545
E1095 out1095 0 ref1095 fb1095 1e6
R3_1095 out1095 fb1095 100404.771
R4_1095 fb1095 0 21815.3797
Rl1095 out1095 0 10
Vr1096 ref1096 0 0.609871884
E1096 out1096 0 ref1096 fb1096 1e6
R3_1096 out1096 fb1096 99081.0876
R4_1096 fb1096 0 22169.0065
Rl1096 out1096 0 10
Vr1097 ref1097 0 0.596135511
E1097 out1097 0 ref1097 fb1097 1e6
R3_1097 out1097 fb1097 99231.6497
R4_1097 fb1097 0 22023.2888
Rl1097 out1097 0 10
Vr1098 ref1098 0 0.611621345
E1098 out1098 0 ref1098 fb1098 1e6
R3_1098 out1098 fb1098 99510.0591
R4_1098 fb1098 0 21939.8188
Rl1098 out1098 0 10
Vr1099 ref1099 0 0.594180734
E1099 out1099 0 ref1099 fb1099 1e6
R3_1099 out1099 fb1099 100790.471
R4_1099 fb1099 0 22086.0048
Rl1099 out1099 0 10
Vr1100 ref1100 0 0.610932128
E1100 out1100 0 ref1100 fb1100 1e6
R3_1100 out1100 fb1100 100084.767
R4_1100 fb1100 0 22088.4175
Rl1100 out1100 0 10
Vr1101 ref1101 0 0.610141325
E1101 out1101 0 ref1101 fb1101 1e6
R3_1101 out1101 fb1101 100115.629
R4_1101 fb1101 0 21914.9879
Rl1101 out1101 0 10
Vr1102 ref1102 0 0.592045943
E1102 out1102 0 ref1102 fb1102 1e6
R3_1102 out1102 fb1102 99383.7757
R4_1102 fb1102 0 21905.4645
Rl1102 out1102 0 10
Vr1103 ref1103 0 0.605012654
E1103 out1103 0 ref1103 fb1103 1e6
R3_1103 out1103 fb1103 99356.6006
R4_1103 fb1103 0 22201.2426
Rl1103 out1103 0 10
Vr1104 ref1104 0 0.595541323
E1104 out1104 0 ref1104 fb1104 1e6
R3_1104 out1104 fb1104 100622.295
R4_1104 fb1104 0 21883.1546
Rl1104 out1104 0 10
Vr1105 ref1105 0 0.599493321
E1105 out1105 0 ref1105 fb1105 1e6
R3_1105 out1105 fb1105 100398.157
R4_1105 fb1105 0 21984.7624
Rl1105 out1105 0 10
Vr1106 ref1106 0 0.595344311
E1106 out1106 0 ref1106 fb1106 1e6
R3_1106 out1106 fb1106 100668.756
R4_1106 fb1106 0 22187.4527
Rl1106 out1106 0 10
Vr1107 ref1107 0 0.601458652
E1107 out1107 0 ref1107 fb1107 1e6
R3_1107 out1107 fb1107 100044.466
R4_1107 fb1107 0 22010.318
Rl1107 out1107 0 10
Vr1108 ref1108 0 0.610637957
E1108 out1108 0 ref1108 fb1108 1e6
R3_1108 out1108 fb1108 100112.908
R4_1108 fb1108 0 21999.4445
Rl1108 out1108 0 10
Vr1109 ref1109 0 0.606844397
E1109 out1109 0 ref1109 fb1109 1e6
R3_1109 out1109 fb1109 99326.3243
R4_1109 fb1109 0 22031.4617
Rl1109 out1109 0 10
Vr1110 ref1110 0 0.596639586
E1110 out1110 0 ref1110 fb1110 1e6
R3_1110 out1110 fb1110 99209.7479
R4_1110 fb1110 0 22202.7628
Rl1110 out1110 0 10
Vr1111 ref1111 0 0.610588896
E1111 out1111 0 ref1111 fb1111 1e6
R3_1111 out1111 fb1111 99312.3805
R4_1111 fb1111 0 22208.0876
Rl1111 out1111 0 10
Vr1112 ref1112 0 0.607408448
E1112 out1112 0 ref1112 fb1112 1e6
R3_1112 out1112 fb1112 99657.2876
R4_1112 fb1112 0 22099.2591
Rl1112 out1112 0 10
Vr1113 ref1113 0 0.598977279
E1113 out1113 0 ref1113 fb1113 1e6
R3_1113 out1113 fb1113 100335.469
R4_1113 fb1113 0 21797.3097
Rl1113 out1113 0 10
Vr1114 ref1114 0 0.606993161
E1114 out1114 0 ref1114 fb1114 1e6
R3_1114 out1114 fb1114 100211.751
R4_1114 fb1114 0 21870.0708
Rl1114 out1114 0 10
Vr1115 ref1115 0 0.593987164
E1115 out1115 0 ref1115 fb1115 1e6
R3_1115 out1115 fb1115 99871.8751
R4_1115 fb1115 0 22074.5303
Rl1115 out1115 0 10
Vr1116 ref1116 0 0.599070237
E1116 out1116 0 ref1116 fb1116 1e6
R3_1116 out1116 fb1116 99692.0575
R4_1116 fb1116 0 21797.9924
Rl1116 out1116 0 10
Vr1117 ref1117 0 0.599082741
E1117 out1117 0 ref1117 fb1117 1e6
R3_1117 out1117 fb1117 100301.433
R4_1117 fb1117 0 22096.5542
Rl1117 out1117 0 10
Vr1118 ref1118 0 0.590767561
E1118 out1118 0 ref1118 fb1118 1e6
R3_1118 out1118 fb1118 99576.9527
R4_1118 fb1118 0 22188.9253
Rl1118 out1118 0 10
Vr1119 ref1119 0 0.60689069
E1119 out1119 0 ref1119 fb1119 1e6
R3_1119 out1119 fb1119 100918.531
R4_1119 fb1119 0 22070.3518
Rl1119 out1119 0 10
Vr1120 ref1120 0 0.607511975
E1120 out1120 0 ref1120 fb1120 1e6
R3_1120 out1120 fb1120 99296.1637
R4_1120 fb1120 0 22140.736
Rl1120 out1120 0 10
Vr1121 ref1121 0 0.603456405
E1121 out1121 0 ref1121 fb1121 1e6
R3_1121 out1121 fb1121 99216.0507
R4_1121 fb1121 0 21801.9821
Rl1121 out1121 0 10
Vr1122 ref1122 0 0.605661143
E1122 out1122 0 ref1122 fb1122 1e6
R3_1122 out1122 fb1122 99885.6775
R4_1122 fb1122 0 21876.7879
Rl1122 out1122 0 10
Vr1123 ref1123 0 0.593182214
E1123 out1123 0 ref1123 fb1123 1e6
R3_1123 out1123 fb1123 100189.398
R4_1123 fb1123 0 22173.8436
Rl1123 out1123 0 10
Vr1124 ref1124 0 0.605551436
E1124 out1124 0 ref1124 fb1124 1e6
R3_1124 out1124 fb1124 100212.931
R4_1124 fb1124 0 22167.4034
Rl1124 out1124 0 10
Vr1125 ref1125 0 0.589007214
E1125 out1125 0 ref1125 fb1125 1e6
R3_1125 out1125 fb1125 100487.218
R4_1125 fb1125 0 22172.2175
Rl1125 out1125 0 10
Vr1126 ref1126 0 0.597977832
E1126 out1126 0 ref1126 fb1126 1e6
R3_1126 out1126 fb1126 99533.7351
R4_1126 fb1126 0 21954.0666
Rl1126 out1126 0 10
Vr1127 ref1127 0 0.600322022
E1127 out1127 0 ref1127 fb1127 1e6
R3_1127 out1127 fb1127 99878.2228
R4_1127 fb1127 0 21953.2926
Rl1127 out1127 0 10
Vr1128 ref1128 0 0.611757299
E1128 out1128 0 ref1128 fb1128 1e6
R3_1128 out1128 fb1128 99339.8037
R4_1128 fb1128 0 22024.9213
Rl1128 out1128 0 10
Vr1129 ref1129 0 0.594970427
E1129 out1129 0 ref1129 fb1129 1e6
R3_1129 out1129 fb1129 100016.556
R4_1129 fb1129 0 21999.8663
Rl1129 out1129 0 10
Vr1130 ref1130 0 0.606209037
E1130 out1130 0 ref1130 fb1130 1e6
R3_1130 out1130 fb1130 99518.7047
R4_1130 fb1130 0 22123.8107
Rl1130 out1130 0 10
Vr1131 ref1131 0 0.589531836
E1131 out1131 0 ref1131 fb1131 1e6
R3_1131 out1131 fb1131 100280.033
R4_1131 fb1131 0 21923.1385
Rl1131 out1131 0 10
Vr1132 ref1132 0 0.601759329
E1132 out1132 0 ref1132 fb1132 1e6
R3_1132 out1132 fb1132 100784.757
R4_1132 fb1132 0 21898.7648
Rl1132 out1132 0 10
Vr1133 ref1133 0 0.589656322
E1133 out1133 0 ref1133 fb1133 1e6
R3_1133 out1133 fb1133 100567.442
R4_1133 fb1133 0 22070.4041
Rl1133 out1133 0 10
Vr1134 ref1134 0 0.608648728
E1134 out1134 0 ref1134 fb1134 1e6
R3_1134 out1134 fb1134 99543.5065
R4_1134 fb1134 0 22104.8995
Rl1134 out1134 0 10
Vr1135 ref1135 0 0.600604505
E1135 out1135 0 ref1135 fb1135 1e6
R3_1135 out1135 fb1135 99943.5176
R4_1135 fb1135 0 21836.0394
Rl1135 out1135 0 10
Vr1136 ref1136 0 0.600038187
E1136 out1136 0 ref1136 fb1136 1e6
R3_1136 out1136 fb1136 100974.834
R4_1136 fb1136 0 22114.8199
Rl1136 out1136 0 10
Vr1137 ref1137 0 0.60681782
E1137 out1137 0 ref1137 fb1137 1e6
R3_1137 out1137 fb1137 99624.8211
R4_1137 fb1137 0 22132.6635
Rl1137 out1137 0 10
Vr1138 ref1138 0 0.59529866
E1138 out1138 0 ref1138 fb1138 1e6
R3_1138 out1138 fb1138 100416.883
R4_1138 fb1138 0 22107.1501
Rl1138 out1138 0 10
Vr1139 ref1139 0 0.591274998
E1139 out1139 0 ref1139 fb1139 1e6
R3_1139 out1139 fb1139 99331.2673
R4_1139 fb1139 0 22172.7715
Rl1139 out1139 0 10
Vr1140 ref1140 0 0.598298015
E1140 out1140 0 ref1140 fb1140 1e6
R3_1140 out1140 fb1140 100699.978
R4_1140 fb1140 0 21960.5907
Rl1140 out1140 0 10
Vr1141 ref1141 0 0.59958166
E1141 out1141 0 ref1141 fb1141 1e6
R3_1141 out1141 fb1141 100471.403
R4_1141 fb1141 0 21786.196
Rl1141 out1141 0 10
Vr1142 ref1142 0 0.611019902
E1142 out1142 0 ref1142 fb1142 1e6
R3_1142 out1142 fb1142 100502.683
R4_1142 fb1142 0 22207.2351
Rl1142 out1142 0 10
Vr1143 ref1143 0 0.588485069
E1143 out1143 0 ref1143 fb1143 1e6
R3_1143 out1143 fb1143 100361.735
R4_1143 fb1143 0 22040.2202
Rl1143 out1143 0 10
Vr1144 ref1144 0 0.606191335
E1144 out1144 0 ref1144 fb1144 1e6
R3_1144 out1144 fb1144 100241.209
R4_1144 fb1144 0 21795.7842
Rl1144 out1144 0 10
Vr1145 ref1145 0 0.600865582
E1145 out1145 0 ref1145 fb1145 1e6
R3_1145 out1145 fb1145 99855.498
R4_1145 fb1145 0 22174.109
Rl1145 out1145 0 10
Vr1146 ref1146 0 0.598625517
E1146 out1146 0 ref1146 fb1146 1e6
R3_1146 out1146 fb1146 99898.9004
R4_1146 fb1146 0 21905.3602
Rl1146 out1146 0 10
Vr1147 ref1147 0 0.604997585
E1147 out1147 0 ref1147 fb1147 1e6
R3_1147 out1147 fb1147 100063.825
R4_1147 fb1147 0 21961.0175
Rl1147 out1147 0 10
Vr1148 ref1148 0 0.598492206
E1148 out1148 0 ref1148 fb1148 1e6
R3_1148 out1148 fb1148 100737.447
R4_1148 fb1148 0 22001.8013
Rl1148 out1148 0 10
Vr1149 ref1149 0 0.597838633
E1149 out1149 0 ref1149 fb1149 1e6
R3_1149 out1149 fb1149 100022.467
R4_1149 fb1149 0 22179.0101
Rl1149 out1149 0 10
Vr1150 ref1150 0 0.588205113
E1150 out1150 0 ref1150 fb1150 1e6
R3_1150 out1150 fb1150 100688.353
R4_1150 fb1150 0 21926.9744
Rl1150 out1150 0 10
Vr1151 ref1151 0 0.602919365
E1151 out1151 0 ref1151 fb1151 1e6
R3_1151 out1151 fb1151 100889.594
R4_1151 fb1151 0 21851.5613
Rl1151 out1151 0 10
Vr1152 ref1152 0 0.594067853
E1152 out1152 0 ref1152 fb1152 1e6
R3_1152 out1152 fb1152 99763.3376
R4_1152 fb1152 0 22018.2878
Rl1152 out1152 0 10
Vr1153 ref1153 0 0.60799571
E1153 out1153 0 ref1153 fb1153 1e6
R3_1153 out1153 fb1153 99818.1701
R4_1153 fb1153 0 21885.4649
Rl1153 out1153 0 10
Vr1154 ref1154 0 0.598442673
E1154 out1154 0 ref1154 fb1154 1e6
R3_1154 out1154 fb1154 100178.525
R4_1154 fb1154 0 22118.7691
Rl1154 out1154 0 10
Vr1155 ref1155 0 0.610790185
E1155 out1155 0 ref1155 fb1155 1e6
R3_1155 out1155 fb1155 100261.53
R4_1155 fb1155 0 21837.7715
Rl1155 out1155 0 10
Vr1156 ref1156 0 0.59165666
E1156 out1156 0 ref1156 fb1156 1e6
R3_1156 out1156 fb1156 100890.09
R4_1156 fb1156 0 21854.403
Rl1156 out1156 0 10
Vr1157 ref1157 0 0.603584913
E1157 out1157 0 ref1157 fb1157 1e6
R3_1157 out1157 fb1157 100190.861
R4_1157 fb1157 0 21955.8489
Rl1157 out1157 0 10
Vr1158 ref1158 0 0.599600789
E1158 out1158 0 ref1158 fb1158 1e6
R3_1158 out1158 fb1158 99579.6553
R4_1158 fb1158 0 21864.4852
Rl1158 out1158 0 10
Vr1159 ref1159 0 0.598333154
E1159 out1159 0 ref1159 fb1159 1e6
R3_1159 out1159 fb1159 99921.679
R4_1159 fb1159 0 21888.478
Rl1159 out1159 0 10
Vr1160 ref1160 0 0.600778209
E1160 out1160 0 ref1160 fb1160 1e6
R3_1160 out1160 fb1160 100834.424
R4_1160 fb1160 0 22018.3393
Rl1160 out1160 0 10
Vr1161 ref1161 0 0.605783575
E1161 out1161 0 ref1161 fb1161 1e6
R3_1161 out1161 fb1161 100121.604
R4_1161 fb1161 0 21970.4708
Rl1161 out1161 0 10
Vr1162 ref1162 0 0.590927463
E1162 out1162 0 ref1162 fb1162 1e6
R3_1162 out1162 fb1162 99156.0249
R4_1162 fb1162 0 21823.9982
Rl1162 out1162 0 10
Vr1163 ref1163 0 0.597852628
E1163 out1163 0 ref1163 fb1163 1e6
R3_1163 out1163 fb1163 99577.0193
R4_1163 fb1163 0 21917.0035
Rl1163 out1163 0 10
Vr1164 ref1164 0 0.607276581
E1164 out1164 0 ref1164 fb1164 1e6
R3_1164 out1164 fb1164 100202.156
R4_1164 fb1164 0 22002.4768
Rl1164 out1164 0 10
Vr1165 ref1165 0 0.592708949
E1165 out1165 0 ref1165 fb1165 1e6
R3_1165 out1165 fb1165 99640.8165
R4_1165 fb1165 0 22207.6067
Rl1165 out1165 0 10
Vr1166 ref1166 0 0.604609723
E1166 out1166 0 ref1166 fb1166 1e6
R3_1166 out1166 fb1166 100547.283
R4_1166 fb1166 0 21915.2096
Rl1166 out1166 0 10
Vr1167 ref1167 0 0.60841698
E1167 out1167 0 ref1167 fb1167 1e6
R3_1167 out1167 fb1167 100278.386
R4_1167 fb1167 0 21888.3375
Rl1167 out1167 0 10
Vr1168 ref1168 0 0.607392305
E1168 out1168 0 ref1168 fb1168 1e6
R3_1168 out1168 fb1168 99936.4251
R4_1168 fb1168 0 21905.5962
Rl1168 out1168 0 10
Vr1169 ref1169 0 0.598289828
E1169 out1169 0 ref1169 fb1169 1e6
R3_1169 out1169 fb1169 99281.5261
R4_1169 fb1169 0 21940.4289
Rl1169 out1169 0 10
Vr1170 ref1170 0 0.593070018
E1170 out1170 0 ref1170 fb1170 1e6
R3_1170 out1170 fb1170 100214.1
R4_1170 fb1170 0 22202.5188
Rl1170 out1170 0 10
Vr1171 ref1171 0 0.610169413
E1171 out1171 0 ref1171 fb1171 1e6
R3_1171 out1171 fb1171 100125.488
R4_1171 fb1171 0 21864.4885
Rl1171 out1171 0 10
Vr1172 ref1172 0 0.589126115
E1172 out1172 0 ref1172 fb1172 1e6
R3_1172 out1172 fb1172 99709.3641
R4_1172 fb1172 0 21869.9666
Rl1172 out1172 0 10
Vr1173 ref1173 0 0.610462776
E1173 out1173 0 ref1173 fb1173 1e6
R3_1173 out1173 fb1173 99699.1658
R4_1173 fb1173 0 22091.9286
Rl1173 out1173 0 10
Vr1174 ref1174 0 0.606765221
E1174 out1174 0 ref1174 fb1174 1e6
R3_1174 out1174 fb1174 99678.7905
R4_1174 fb1174 0 22187.7258
Rl1174 out1174 0 10
Vr1175 ref1175 0 0.59061779
E1175 out1175 0 ref1175 fb1175 1e6
R3_1175 out1175 fb1175 99298.8599
R4_1175 fb1175 0 21992.7812
Rl1175 out1175 0 10
Vr1176 ref1176 0 0.610102637
E1176 out1176 0 ref1176 fb1176 1e6
R3_1176 out1176 fb1176 100843.504
R4_1176 fb1176 0 22085.7265
Rl1176 out1176 0 10
Vr1177 ref1177 0 0.596650036
E1177 out1177 0 ref1177 fb1177 1e6
R3_1177 out1177 fb1177 100549.528
R4_1177 fb1177 0 22036.4205
Rl1177 out1177 0 10
Vr1178 ref1178 0 0.605712524
E1178 out1178 0 ref1178 fb1178 1e6
R3_1178 out1178 fb1178 99475.242
R4_1178 fb1178 0 21986.3696
Rl1178 out1178 0 10
Vr1179 ref1179 0 0.611543459
E1179 out1179 0 ref1179 fb1179 1e6
R3_1179 out1179 fb1179 100896.214
R4_1179 fb1179 0 21840.3073
Rl1179 out1179 0 10
Vr1180 ref1180 0 0.596210222
E1180 out1180 0 ref1180 fb1180 1e6
R3_1180 out1180 fb1180 100808.586
R4_1180 fb1180 0 22095.4581
Rl1180 out1180 0 10
Vr1181 ref1181 0 0.597333752
E1181 out1181 0 ref1181 fb1181 1e6
R3_1181 out1181 fb1181 99029.6066
R4_1181 fb1181 0 21853.1852
Rl1181 out1181 0 10
Vr1182 ref1182 0 0.595981071
E1182 out1182 0 ref1182 fb1182 1e6
R3_1182 out1182 fb1182 100967.231
R4_1182 fb1182 0 22052.1291
Rl1182 out1182 0 10
Vr1183 ref1183 0 0.611786154
E1183 out1183 0 ref1183 fb1183 1e6
R3_1183 out1183 fb1183 100582.708
R4_1183 fb1183 0 21884.08
Rl1183 out1183 0 10
Vr1184 ref1184 0 0.608314825
E1184 out1184 0 ref1184 fb1184 1e6
R3_1184 out1184 fb1184 100686.566
R4_1184 fb1184 0 22140.6346
Rl1184 out1184 0 10
Vr1185 ref1185 0 0.609081034
E1185 out1185 0 ref1185 fb1185 1e6
R3_1185 out1185 fb1185 99520.1243
R4_1185 fb1185 0 21872.6029
Rl1185 out1185 0 10
Vr1186 ref1186 0 0.591711145
E1186 out1186 0 ref1186 fb1186 1e6
R3_1186 out1186 fb1186 100925.626
R4_1186 fb1186 0 22196.2583
Rl1186 out1186 0 10
Vr1187 ref1187 0 0.590628475
E1187 out1187 0 ref1187 fb1187 1e6
R3_1187 out1187 fb1187 100731.074
R4_1187 fb1187 0 21996.8733
Rl1187 out1187 0 10
Vr1188 ref1188 0 0.599892877
E1188 out1188 0 ref1188 fb1188 1e6
R3_1188 out1188 fb1188 100184.799
R4_1188 fb1188 0 22141.4426
Rl1188 out1188 0 10
Vr1189 ref1189 0 0.589887617
E1189 out1189 0 ref1189 fb1189 1e6
R3_1189 out1189 fb1189 99114.9589
R4_1189 fb1189 0 22127.9942
Rl1189 out1189 0 10
Vr1190 ref1190 0 0.596272588
E1190 out1190 0 ref1190 fb1190 1e6
R3_1190 out1190 fb1190 100567.518
R4_1190 fb1190 0 21897.9988
Rl1190 out1190 0 10
Vr1191 ref1191 0 0.599273254
E1191 out1191 0 ref1191 fb1191 1e6
R3_1191 out1191 fb1191 99858.5294
R4_1191 fb1191 0 22154.8405
Rl1191 out1191 0 10
Vr1192 ref1192 0 0.588139051
E1192 out1192 0 ref1192 fb1192 1e6
R3_1192 out1192 fb1192 100650.011
R4_1192 fb1192 0 22183.0012
Rl1192 out1192 0 10
Vr1193 ref1193 0 0.604036565
E1193 out1193 0 ref1193 fb1193 1e6
R3_1193 out1193 fb1193 100504.223
R4_1193 fb1193 0 21891.0689
Rl1193 out1193 0 10
Vr1194 ref1194 0 0.596211157
E1194 out1194 0 ref1194 fb1194 1e6
R3_1194 out1194 fb1194 100607.856
R4_1194 fb1194 0 21914.611
Rl1194 out1194 0 10
Vr1195 ref1195 0 0.598636273
E1195 out1195 0 ref1195 fb1195 1e6
R3_1195 out1195 fb1195 99080.9045
R4_1195 fb1195 0 22178.8841
Rl1195 out1195 0 10
Vr1196 ref1196 0 0.609187122
E1196 out1196 0 ref1196 fb1196 1e6
R3_1196 out1196 fb1196 99033.9441
R4_1196 fb1196 0 22009.4096
Rl1196 out1196 0 10
Vr1197 ref1197 0 0.600628587
E1197 out1197 0 ref1197 fb1197 1e6
R3_1197 out1197 fb1197 99309.669
R4_1197 fb1197 0 21949.0899
Rl1197 out1197 0 10
Vr1198 ref1198 0 0.605269191
E1198 out1198 0 ref1198 fb1198 1e6
R3_1198 out1198 fb1198 100882.879
R4_1198 fb1198 0 22025.9068
Rl1198 out1198 0 10
Vr1199 ref1199 0 0.602681711
E1199 out1199 0 ref1199 fb1199 1e6
R3_1199 out1199 fb1199 99437.3767
R4_1199 fb1199 0 22004.5558
Rl1199 out1199 0 10
Vr1200 ref1200 0 0.590739665
E1200 out1200 0 ref1200 fb1200 1e6
R3_1200 out1200 fb1200 100681.223
R4_1200 fb1200 0 22170.3475
Rl1200 out1200 0 10
Vr1201 ref1201 0 0.589221695
E1201 out1201 0 ref1201 fb1201 1e6
R3_1201 out1201 fb1201 99408.2677
R4_1201 fb1201 0 22040.282
Rl1201 out1201 0 10
Vr1202 ref1202 0 0.593073992
E1202 out1202 0 ref1202 fb1202 1e6
R3_1202 out1202 fb1202 100343.173
R4_1202 fb1202 0 22100.4414
Rl1202 out1202 0 10
Vr1203 ref1203 0 0.596024247
E1203 out1203 0 ref1203 fb1203 1e6
R3_1203 out1203 fb1203 100690.932
R4_1203 fb1203 0 21934.0455
Rl1203 out1203 0 10
Vr1204 ref1204 0 0.607355023
E1204 out1204 0 ref1204 fb1204 1e6
R3_1204 out1204 fb1204 100728.274
R4_1204 fb1204 0 22093.0692
Rl1204 out1204 0 10
Vr1205 ref1205 0 0.607918108
E1205 out1205 0 ref1205 fb1205 1e6
R3_1205 out1205 fb1205 99650.0584
R4_1205 fb1205 0 21923.9395
Rl1205 out1205 0 10
Vr1206 ref1206 0 0.590722153
E1206 out1206 0 ref1206 fb1206 1e6
R3_1206 out1206 fb1206 99627.4861
R4_1206 fb1206 0 21861.0563
Rl1206 out1206 0 10
Vr1207 ref1207 0 0.606805185
E1207 out1207 0 ref1207 fb1207 1e6
R3_1207 out1207 fb1207 99357.1808
R4_1207 fb1207 0 22150.221
Rl1207 out1207 0 10
Vr1208 ref1208 0 0.599382015
E1208 out1208 0 ref1208 fb1208 1e6
R3_1208 out1208 fb1208 99326.3588
R4_1208 fb1208 0 21784.8202
Rl1208 out1208 0 10
Vr1209 ref1209 0 0.610918135
E1209 out1209 0 ref1209 fb1209 1e6
R3_1209 out1209 fb1209 99917.6556
R4_1209 fb1209 0 22006.3015
Rl1209 out1209 0 10
Vr1210 ref1210 0 0.592145015
E1210 out1210 0 ref1210 fb1210 1e6
R3_1210 out1210 fb1210 99678.8165
R4_1210 fb1210 0 22123.5242
Rl1210 out1210 0 10
Vr1211 ref1211 0 0.610906862
E1211 out1211 0 ref1211 fb1211 1e6
R3_1211 out1211 fb1211 100106.731
R4_1211 fb1211 0 21815.8495
Rl1211 out1211 0 10
Vr1212 ref1212 0 0.59311692
E1212 out1212 0 ref1212 fb1212 1e6
R3_1212 out1212 fb1212 100208.224
R4_1212 fb1212 0 21820.4694
Rl1212 out1212 0 10
Vr1213 ref1213 0 0.609604012
E1213 out1213 0 ref1213 fb1213 1e6
R3_1213 out1213 fb1213 99907.0668
R4_1213 fb1213 0 22210.7176
Rl1213 out1213 0 10
Vr1214 ref1214 0 0.593483061
E1214 out1214 0 ref1214 fb1214 1e6
R3_1214 out1214 fb1214 99734.6765
R4_1214 fb1214 0 22118.5384
Rl1214 out1214 0 10
Vr1215 ref1215 0 0.591393397
E1215 out1215 0 ref1215 fb1215 1e6
R3_1215 out1215 fb1215 100061.446
R4_1215 fb1215 0 22051.2145
Rl1215 out1215 0 10
Vr1216 ref1216 0 0.602840407
E1216 out1216 0 ref1216 fb1216 1e6
R3_1216 out1216 fb1216 100803.074
R4_1216 fb1216 0 22087.239
Rl1216 out1216 0 10
Vr1217 ref1217 0 0.590120055
E1217 out1217 0 ref1217 fb1217 1e6
R3_1217 out1217 fb1217 100034.139
R4_1217 fb1217 0 22017.0579
Rl1217 out1217 0 10
Vr1218 ref1218 0 0.598070309
E1218 out1218 0 ref1218 fb1218 1e6
R3_1218 out1218 fb1218 99876.0272
R4_1218 fb1218 0 21824.7244
Rl1218 out1218 0 10
Vr1219 ref1219 0 0.608204505
E1219 out1219 0 ref1219 fb1219 1e6
R3_1219 out1219 fb1219 100142.672
R4_1219 fb1219 0 22121.0169
Rl1219 out1219 0 10
Vr1220 ref1220 0 0.600212029
E1220 out1220 0 ref1220 fb1220 1e6
R3_1220 out1220 fb1220 99576.8
R4_1220 fb1220 0 21952.3378
Rl1220 out1220 0 10
Vr1221 ref1221 0 0.600005706
E1221 out1221 0 ref1221 fb1221 1e6
R3_1221 out1221 fb1221 100259.871
R4_1221 fb1221 0 21881.3866
Rl1221 out1221 0 10
Vr1222 ref1222 0 0.611972803
E1222 out1222 0 ref1222 fb1222 1e6
R3_1222 out1222 fb1222 100844.24
R4_1222 fb1222 0 21815.044
Rl1222 out1222 0 10
Vr1223 ref1223 0 0.599814895
E1223 out1223 0 ref1223 fb1223 1e6
R3_1223 out1223 fb1223 99831.1857
R4_1223 fb1223 0 22001.497
Rl1223 out1223 0 10
Vr1224 ref1224 0 0.608597985
E1224 out1224 0 ref1224 fb1224 1e6
R3_1224 out1224 fb1224 99278.6587
R4_1224 fb1224 0 21992.0095
Rl1224 out1224 0 10
Vr1225 ref1225 0 0.60532553
E1225 out1225 0 ref1225 fb1225 1e6
R3_1225 out1225 fb1225 99880.073
R4_1225 fb1225 0 21812.668
Rl1225 out1225 0 10
Vr1226 ref1226 0 0.606556518
E1226 out1226 0 ref1226 fb1226 1e6
R3_1226 out1226 fb1226 99745.4563
R4_1226 fb1226 0 21957.2108
Rl1226 out1226 0 10
Vr1227 ref1227 0 0.609348722
E1227 out1227 0 ref1227 fb1227 1e6
R3_1227 out1227 fb1227 100837.533
R4_1227 fb1227 0 21810.0074
Rl1227 out1227 0 10
Vr1228 ref1228 0 0.610192555
E1228 out1228 0 ref1228 fb1228 1e6
R3_1228 out1228 fb1228 99281.8533
R4_1228 fb1228 0 21786.1033
Rl1228 out1228 0 10
Vr1229 ref1229 0 0.602118732
E1229 out1229 0 ref1229 fb1229 1e6
R3_1229 out1229 fb1229 100462.207
R4_1229 fb1229 0 21915.9476
Rl1229 out1229 0 10
Vr1230 ref1230 0 0.589573868
E1230 out1230 0 ref1230 fb1230 1e6
R3_1230 out1230 fb1230 100643.829
R4_1230 fb1230 0 22019.0698
Rl1230 out1230 0 10
Vr1231 ref1231 0 0.590531798
E1231 out1231 0 ref1231 fb1231 1e6
R3_1231 out1231 fb1231 99454.1717
R4_1231 fb1231 0 21968.1757
Rl1231 out1231 0 10
Vr1232 ref1232 0 0.596421706
E1232 out1232 0 ref1232 fb1232 1e6
R3_1232 out1232 fb1232 99804.5365
R4_1232 fb1232 0 22089.3289
Rl1232 out1232 0 10
Vr1233 ref1233 0 0.59889395
E1233 out1233 0 ref1233 fb1233 1e6
R3_1233 out1233 fb1233 100458.011
R4_1233 fb1233 0 21958.644
Rl1233 out1233 0 10
Vr1234 ref1234 0 0.597845942
E1234 out1234 0 ref1234 fb1234 1e6
R3_1234 out1234 fb1234 99264.9387
R4_1234 fb1234 0 22087.6892
Rl1234 out1234 0 10
Vr1235 ref1235 0 0.59276915
E1235 out1235 0 ref1235 fb1235 1e6
R3_1235 out1235 fb1235 100148.657
R4_1235 fb1235 0 21898.9223
Rl1235 out1235 0 10
Vr1236 ref1236 0 0.592636443
E1236 out1236 0 ref1236 fb1236 1e6
R3_1236 out1236 fb1236 99471.8909
R4_1236 fb1236 0 21881.8311
Rl1236 out1236 0 10
Vr1237 ref1237 0 0.588579585
E1237 out1237 0 ref1237 fb1237 1e6
R3_1237 out1237 fb1237 99437.1921
R4_1237 fb1237 0 22218.7531
Rl1237 out1237 0 10
Vr1238 ref1238 0 0.591382979
E1238 out1238 0 ref1238 fb1238 1e6
R3_1238 out1238 fb1238 100436.292
R4_1238 fb1238 0 22032.0256
Rl1238 out1238 0 10
Vr1239 ref1239 0 0.599034473
E1239 out1239 0 ref1239 fb1239 1e6
R3_1239 out1239 fb1239 100905.194
R4_1239 fb1239 0 22185.0792
Rl1239 out1239 0 10
Vr1240 ref1240 0 0.598986469
E1240 out1240 0 ref1240 fb1240 1e6
R3_1240 out1240 fb1240 100538.999
R4_1240 fb1240 0 21852.9993
Rl1240 out1240 0 10
Vr1241 ref1241 0 0.605414307
E1241 out1241 0 ref1241 fb1241 1e6
R3_1241 out1241 fb1241 100787.469
R4_1241 fb1241 0 22105.1715
Rl1241 out1241 0 10
Vr1242 ref1242 0 0.597876871
E1242 out1242 0 ref1242 fb1242 1e6
R3_1242 out1242 fb1242 99253.514
R4_1242 fb1242 0 21824.0609
Rl1242 out1242 0 10
Vr1243 ref1243 0 0.602724469
E1243 out1243 0 ref1243 fb1243 1e6
R3_1243 out1243 fb1243 100140.201
R4_1243 fb1243 0 21858.8171
Rl1243 out1243 0 10
Vr1244 ref1244 0 0.600742775
E1244 out1244 0 ref1244 fb1244 1e6
R3_1244 out1244 fb1244 100460.157
R4_1244 fb1244 0 22030.2787
Rl1244 out1244 0 10
Vr1245 ref1245 0 0.604847646
E1245 out1245 0 ref1245 fb1245 1e6
R3_1245 out1245 fb1245 99580.789
R4_1245 fb1245 0 22045.4527
Rl1245 out1245 0 10
Vr1246 ref1246 0 0.609251943
E1246 out1246 0 ref1246 fb1246 1e6
R3_1246 out1246 fb1246 99749.7071
R4_1246 fb1246 0 22149.8419
Rl1246 out1246 0 10
Vr1247 ref1247 0 0.598369619
E1247 out1247 0 ref1247 fb1247 1e6
R3_1247 out1247 fb1247 100458.914
R4_1247 fb1247 0 22004.8669
Rl1247 out1247 0 10
Vr1248 ref1248 0 0.590206346
E1248 out1248 0 ref1248 fb1248 1e6
R3_1248 out1248 fb1248 99223.3096
R4_1248 fb1248 0 22124.1097
Rl1248 out1248 0 10
Vr1249 ref1249 0 0.60525582
E1249 out1249 0 ref1249 fb1249 1e6
R3_1249 out1249 fb1249 100261.891
R4_1249 fb1249 0 22089.6726
Rl1249 out1249 0 10
Vr1250 ref1250 0 0.588154999
E1250 out1250 0 ref1250 fb1250 1e6
R3_1250 out1250 fb1250 99046.7257
R4_1250 fb1250 0 22074.1032
Rl1250 out1250 0 10
Vr1251 ref1251 0 0.608361916
E1251 out1251 0 ref1251 fb1251 1e6
R3_1251 out1251 fb1251 99987.2902
R4_1251 fb1251 0 22127.828
Rl1251 out1251 0 10
Vr1252 ref1252 0 0.605711208
E1252 out1252 0 ref1252 fb1252 1e6
R3_1252 out1252 fb1252 100843.991
R4_1252 fb1252 0 21836.4896
Rl1252 out1252 0 10
Vr1253 ref1253 0 0.607285661
E1253 out1253 0 ref1253 fb1253 1e6
R3_1253 out1253 fb1253 99333.0627
R4_1253 fb1253 0 22068.8038
Rl1253 out1253 0 10
Vr1254 ref1254 0 0.605161469
E1254 out1254 0 ref1254 fb1254 1e6
R3_1254 out1254 fb1254 100538.049
R4_1254 fb1254 0 21986.0193
Rl1254 out1254 0 10
Vr1255 ref1255 0 0.599881647
E1255 out1255 0 ref1255 fb1255 1e6
R3_1255 out1255 fb1255 99882.797
R4_1255 fb1255 0 22063.1195
Rl1255 out1255 0 10
Vr1256 ref1256 0 0.592675427
E1256 out1256 0 ref1256 fb1256 1e6
R3_1256 out1256 fb1256 99560.6315
R4_1256 fb1256 0 21879.0945
Rl1256 out1256 0 10
Vr1257 ref1257 0 0.589715638
E1257 out1257 0 ref1257 fb1257 1e6
R3_1257 out1257 fb1257 100444.439
R4_1257 fb1257 0 22157.4416
Rl1257 out1257 0 10
Vr1258 ref1258 0 0.589968417
E1258 out1258 0 ref1258 fb1258 1e6
R3_1258 out1258 fb1258 99481.0296
R4_1258 fb1258 0 22064.3086
Rl1258 out1258 0 10
Vr1259 ref1259 0 0.590322969
E1259 out1259 0 ref1259 fb1259 1e6
R3_1259 out1259 fb1259 100149.037
R4_1259 fb1259 0 22192.3563
Rl1259 out1259 0 10
Vr1260 ref1260 0 0.591721261
E1260 out1260 0 ref1260 fb1260 1e6
R3_1260 out1260 fb1260 99598.5291
R4_1260 fb1260 0 21995.9658
Rl1260 out1260 0 10
Vr1261 ref1261 0 0.596964684
E1261 out1261 0 ref1261 fb1261 1e6
R3_1261 out1261 fb1261 100760.417
R4_1261 fb1261 0 21854.5879
Rl1261 out1261 0 10
Vr1262 ref1262 0 0.591416518
E1262 out1262 0 ref1262 fb1262 1e6
R3_1262 out1262 fb1262 100422.967
R4_1262 fb1262 0 21893.2651
Rl1262 out1262 0 10
Vr1263 ref1263 0 0.601836078
E1263 out1263 0 ref1263 fb1263 1e6
R3_1263 out1263 fb1263 100455.593
R4_1263 fb1263 0 22006.0859
Rl1263 out1263 0 10
Vr1264 ref1264 0 0.590007982
E1264 out1264 0 ref1264 fb1264 1e6
R3_1264 out1264 fb1264 100201.784
R4_1264 fb1264 0 22158.8724
Rl1264 out1264 0 10
Vr1265 ref1265 0 0.607171685
E1265 out1265 0 ref1265 fb1265 1e6
R3_1265 out1265 fb1265 100501.727
R4_1265 fb1265 0 22086.015
Rl1265 out1265 0 10
Vr1266 ref1266 0 0.594134355
E1266 out1266 0 ref1266 fb1266 1e6
R3_1266 out1266 fb1266 100218.878
R4_1266 fb1266 0 22205.338
Rl1266 out1266 0 10
Vr1267 ref1267 0 0.593314287
E1267 out1267 0 ref1267 fb1267 1e6
R3_1267 out1267 fb1267 100873.267
R4_1267 fb1267 0 22208.7278
Rl1267 out1267 0 10
Vr1268 ref1268 0 0.590248335
E1268 out1268 0 ref1268 fb1268 1e6
R3_1268 out1268 fb1268 99241.1922
R4_1268 fb1268 0 22156.9875
Rl1268 out1268 0 10
Vr1269 ref1269 0 0.593345281
E1269 out1269 0 ref1269 fb1269 1e6
R3_1269 out1269 fb1269 99646.8934
R4_1269 fb1269 0 22027.3889
Rl1269 out1269 0 10
Vr1270 ref1270 0 0.600685734
E1270 out1270 0 ref1270 fb1270 1e6
R3_1270 out1270 fb1270 100917.194
R4_1270 fb1270 0 22161.7384
Rl1270 out1270 0 10
Vr1271 ref1271 0 0.597175694
E1271 out1271 0 ref1271 fb1271 1e6
R3_1271 out1271 fb1271 100246.056
R4_1271 fb1271 0 22014.8435
Rl1271 out1271 0 10
Vr1272 ref1272 0 0.593823044
E1272 out1272 0 ref1272 fb1272 1e6
R3_1272 out1272 fb1272 100054.93
R4_1272 fb1272 0 21788.3486
Rl1272 out1272 0 10
Vr1273 ref1273 0 0.606895443
E1273 out1273 0 ref1273 fb1273 1e6
R3_1273 out1273 fb1273 99045.7382
R4_1273 fb1273 0 21981.9226
Rl1273 out1273 0 10
Vr1274 ref1274 0 0.595650826
E1274 out1274 0 ref1274 fb1274 1e6
R3_1274 out1274 fb1274 99533.7402
R4_1274 fb1274 0 22168.1601
Rl1274 out1274 0 10
Vr1275 ref1275 0 0.603868483
E1275 out1275 0 ref1275 fb1275 1e6
R3_1275 out1275 fb1275 100798.247
R4_1275 fb1275 0 22153.2974
Rl1275 out1275 0 10
Vr1276 ref1276 0 0.589738558
E1276 out1276 0 ref1276 fb1276 1e6
R3_1276 out1276 fb1276 100452.03
R4_1276 fb1276 0 22047.2508
Rl1276 out1276 0 10
Vr1277 ref1277 0 0.604629761
E1277 out1277 0 ref1277 fb1277 1e6
R3_1277 out1277 fb1277 99474.8496
R4_1277 fb1277 0 21907.8134
Rl1277 out1277 0 10
Vr1278 ref1278 0 0.597067033
E1278 out1278 0 ref1278 fb1278 1e6
R3_1278 out1278 fb1278 99929.8574
R4_1278 fb1278 0 21857.6855
Rl1278 out1278 0 10
Vr1279 ref1279 0 0.606832281
E1279 out1279 0 ref1279 fb1279 1e6
R3_1279 out1279 fb1279 99108.4585
R4_1279 fb1279 0 22151.0989
Rl1279 out1279 0 10
Vr1280 ref1280 0 0.608984192
E1280 out1280 0 ref1280 fb1280 1e6
R3_1280 out1280 fb1280 99177.1675
R4_1280 fb1280 0 22021.1777
Rl1280 out1280 0 10
Vr1281 ref1281 0 0.590931744
E1281 out1281 0 ref1281 fb1281 1e6
R3_1281 out1281 fb1281 99215.8025
R4_1281 fb1281 0 22051.2223
Rl1281 out1281 0 10
Vr1282 ref1282 0 0.611312688
E1282 out1282 0 ref1282 fb1282 1e6
R3_1282 out1282 fb1282 100544.704
R4_1282 fb1282 0 21956.5223
Rl1282 out1282 0 10
Vr1283 ref1283 0 0.588750197
E1283 out1283 0 ref1283 fb1283 1e6
R3_1283 out1283 fb1283 99963.2206
R4_1283 fb1283 0 22197.5803
Rl1283 out1283 0 10
Vr1284 ref1284 0 0.598111032
E1284 out1284 0 ref1284 fb1284 1e6
R3_1284 out1284 fb1284 99057.4796
R4_1284 fb1284 0 22096.9011
Rl1284 out1284 0 10
Vr1285 ref1285 0 0.599204004
E1285 out1285 0 ref1285 fb1285 1e6
R3_1285 out1285 fb1285 100570.104
R4_1285 fb1285 0 21835.1837
Rl1285 out1285 0 10
Vr1286 ref1286 0 0.601540344
E1286 out1286 0 ref1286 fb1286 1e6
R3_1286 out1286 fb1286 100414.761
R4_1286 fb1286 0 22219.4375
Rl1286 out1286 0 10
Vr1287 ref1287 0 0.591766746
E1287 out1287 0 ref1287 fb1287 1e6
R3_1287 out1287 fb1287 100244.715
R4_1287 fb1287 0 22161.5916
Rl1287 out1287 0 10
Vr1288 ref1288 0 0.594167743
E1288 out1288 0 ref1288 fb1288 1e6
R3_1288 out1288 fb1288 100830.275
R4_1288 fb1288 0 21937.9113
Rl1288 out1288 0 10
Vr1289 ref1289 0 0.600188648
E1289 out1289 0 ref1289 fb1289 1e6
R3_1289 out1289 fb1289 100632.503
R4_1289 fb1289 0 22111.186
Rl1289 out1289 0 10
Vr1290 ref1290 0 0.595508995
E1290 out1290 0 ref1290 fb1290 1e6
R3_1290 out1290 fb1290 100940.449
R4_1290 fb1290 0 22066.7091
Rl1290 out1290 0 10
Vr1291 ref1291 0 0.590922847
E1291 out1291 0 ref1291 fb1291 1e6
R3_1291 out1291 fb1291 100630.203
R4_1291 fb1291 0 22058.2091
Rl1291 out1291 0 10
Vr1292 ref1292 0 0.606403677
E1292 out1292 0 ref1292 fb1292 1e6
R3_1292 out1292 fb1292 99393.0126
R4_1292 fb1292 0 21962.0334
Rl1292 out1292 0 10
Vr1293 ref1293 0 0.610517724
E1293 out1293 0 ref1293 fb1293 1e6
R3_1293 out1293 fb1293 100442.963
R4_1293 fb1293 0 22217.6498
Rl1293 out1293 0 10
Vr1294 ref1294 0 0.592974677
E1294 out1294 0 ref1294 fb1294 1e6
R3_1294 out1294 fb1294 100684.855
R4_1294 fb1294 0 22199.4973
Rl1294 out1294 0 10
Vr1295 ref1295 0 0.60638983
E1295 out1295 0 ref1295 fb1295 1e6
R3_1295 out1295 fb1295 99901.01
R4_1295 fb1295 0 21828.6343
Rl1295 out1295 0 10
Vr1296 ref1296 0 0.592765496
E1296 out1296 0 ref1296 fb1296 1e6
R3_1296 out1296 fb1296 100927.591
R4_1296 fb1296 0 22163.5626
Rl1296 out1296 0 10
Vr1297 ref1297 0 0.597557056
E1297 out1297 0 ref1297 fb1297 1e6
R3_1297 out1297 fb1297 99452.1866
R4_1297 fb1297 0 22070.9617
Rl1297 out1297 0 10
Vr1298 ref1298 0 0.605099738
E1298 out1298 0 ref1298 fb1298 1e6
R3_1298 out1298 fb1298 99829.5455
R4_1298 fb1298 0 21961.1633
Rl1298 out1298 0 10
Vr1299 ref1299 0 0.603764465
E1299 out1299 0 ref1299 fb1299 1e6
R3_1299 out1299 fb1299 100205.716
R4_1299 fb1299 0 22015.614
Rl1299 out1299 0 10
Vr1300 ref1300 0 0.594548311
E1300 out1300 0 ref1300 fb1300 1e6
R3_1300 out1300 fb1300 100557.069
R4_1300 fb1300 0 21940.1848
Rl1300 out1300 0 10
Vr1301 ref1301 0 0.590253548
E1301 out1301 0 ref1301 fb1301 1e6
R3_1301 out1301 fb1301 100744.187
R4_1301 fb1301 0 21866.9562
Rl1301 out1301 0 10
Vr1302 ref1302 0 0.607940723
E1302 out1302 0 ref1302 fb1302 1e6
R3_1302 out1302 fb1302 99592.8727
R4_1302 fb1302 0 21981.2799
Rl1302 out1302 0 10
Vr1303 ref1303 0 0.594162263
E1303 out1303 0 ref1303 fb1303 1e6
R3_1303 out1303 fb1303 100748.519
R4_1303 fb1303 0 22198.9285
Rl1303 out1303 0 10
Vr1304 ref1304 0 0.5928274
E1304 out1304 0 ref1304 fb1304 1e6
R3_1304 out1304 fb1304 99684.5604
R4_1304 fb1304 0 21883.6485
Rl1304 out1304 0 10
Vr1305 ref1305 0 0.605636368
E1305 out1305 0 ref1305 fb1305 1e6
R3_1305 out1305 fb1305 99175.1476
R4_1305 fb1305 0 21989.2757
Rl1305 out1305 0 10
Vr1306 ref1306 0 0.598948456
E1306 out1306 0 ref1306 fb1306 1e6
R3_1306 out1306 fb1306 100640.995
R4_1306 fb1306 0 22094.2125
Rl1306 out1306 0 10
Vr1307 ref1307 0 0.5947648
E1307 out1307 0 ref1307 fb1307 1e6
R3_1307 out1307 fb1307 100516.597
R4_1307 fb1307 0 21838.3553
Rl1307 out1307 0 10
Vr1308 ref1308 0 0.611919038
E1308 out1308 0 ref1308 fb1308 1e6
R3_1308 out1308 fb1308 99545.9458
R4_1308 fb1308 0 22215.5892
Rl1308 out1308 0 10
Vr1309 ref1309 0 0.609596662
E1309 out1309 0 ref1309 fb1309 1e6
R3_1309 out1309 fb1309 100854.69
R4_1309 fb1309 0 22128.4271
Rl1309 out1309 0 10
Vr1310 ref1310 0 0.597653543
E1310 out1310 0 ref1310 fb1310 1e6
R3_1310 out1310 fb1310 100860.007
R4_1310 fb1310 0 21902.2623
Rl1310 out1310 0 10
Vr1311 ref1311 0 0.602186741
E1311 out1311 0 ref1311 fb1311 1e6
R3_1311 out1311 fb1311 99539.2423
R4_1311 fb1311 0 22213.6988
Rl1311 out1311 0 10
Vr1312 ref1312 0 0.598889779
E1312 out1312 0 ref1312 fb1312 1e6
R3_1312 out1312 fb1312 100441.754
R4_1312 fb1312 0 21801.0842
Rl1312 out1312 0 10
Vr1313 ref1313 0 0.590475661
E1313 out1313 0 ref1313 fb1313 1e6
R3_1313 out1313 fb1313 100660.355
R4_1313 fb1313 0 22210.5779
Rl1313 out1313 0 10
Vr1314 ref1314 0 0.603452261
E1314 out1314 0 ref1314 fb1314 1e6
R3_1314 out1314 fb1314 100558.564
R4_1314 fb1314 0 21943.7978
Rl1314 out1314 0 10
Vr1315 ref1315 0 0.595636848
E1315 out1315 0 ref1315 fb1315 1e6
R3_1315 out1315 fb1315 100647.197
R4_1315 fb1315 0 22136.7333
Rl1315 out1315 0 10
Vr1316 ref1316 0 0.609744953
E1316 out1316 0 ref1316 fb1316 1e6
R3_1316 out1316 fb1316 100724.739
R4_1316 fb1316 0 21902.9095
Rl1316 out1316 0 10
Vr1317 ref1317 0 0.609092761
E1317 out1317 0 ref1317 fb1317 1e6
R3_1317 out1317 fb1317 99055.0688
R4_1317 fb1317 0 21792.1788
Rl1317 out1317 0 10
Vr1318 ref1318 0 0.599384925
E1318 out1318 0 ref1318 fb1318 1e6
R3_1318 out1318 fb1318 99088.7914
R4_1318 fb1318 0 21818.051
Rl1318 out1318 0 10
Vr1319 ref1319 0 0.606891819
E1319 out1319 0 ref1319 fb1319 1e6
R3_1319 out1319 fb1319 99877.8004
R4_1319 fb1319 0 21995.8377
Rl1319 out1319 0 10
Vr1320 ref1320 0 0.594314282
E1320 out1320 0 ref1320 fb1320 1e6
R3_1320 out1320 fb1320 99203.7192
R4_1320 fb1320 0 22216.7741
Rl1320 out1320 0 10
Vr1321 ref1321 0 0.605881405
E1321 out1321 0 ref1321 fb1321 1e6
R3_1321 out1321 fb1321 99705.8295
R4_1321 fb1321 0 21896.7068
Rl1321 out1321 0 10
Vr1322 ref1322 0 0.591927419
E1322 out1322 0 ref1322 fb1322 1e6
R3_1322 out1322 fb1322 100618.292
R4_1322 fb1322 0 21944.0678
Rl1322 out1322 0 10
Vr1323 ref1323 0 0.610774691
E1323 out1323 0 ref1323 fb1323 1e6
R3_1323 out1323 fb1323 100189.339
R4_1323 fb1323 0 22218.9911
Rl1323 out1323 0 10
Vr1324 ref1324 0 0.611049281
E1324 out1324 0 ref1324 fb1324 1e6
R3_1324 out1324 fb1324 99952.8233
R4_1324 fb1324 0 22209.0691
Rl1324 out1324 0 10
Vr1325 ref1325 0 0.594512951
E1325 out1325 0 ref1325 fb1325 1e6
R3_1325 out1325 fb1325 99335.4161
R4_1325 fb1325 0 21964.3009
Rl1325 out1325 0 10
Vr1326 ref1326 0 0.603572448
E1326 out1326 0 ref1326 fb1326 1e6
R3_1326 out1326 fb1326 99943.8181
R4_1326 fb1326 0 21812.0895
Rl1326 out1326 0 10
Vr1327 ref1327 0 0.607284312
E1327 out1327 0 ref1327 fb1327 1e6
R3_1327 out1327 fb1327 100338.916
R4_1327 fb1327 0 21987.9227
Rl1327 out1327 0 10
Vr1328 ref1328 0 0.600420967
E1328 out1328 0 ref1328 fb1328 1e6
R3_1328 out1328 fb1328 99629.6599
R4_1328 fb1328 0 21820.7491
Rl1328 out1328 0 10
Vr1329 ref1329 0 0.589747132
E1329 out1329 0 ref1329 fb1329 1e6
R3_1329 out1329 fb1329 100970.773
R4_1329 fb1329 0 22190.4539
Rl1329 out1329 0 10
Vr1330 ref1330 0 0.59493768
E1330 out1330 0 ref1330 fb1330 1e6
R3_1330 out1330 fb1330 99446.7966
R4_1330 fb1330 0 21919.1172
Rl1330 out1330 0 10
Vr1331 ref1331 0 0.608962352
E1331 out1331 0 ref1331 fb1331 1e6
R3_1331 out1331 fb1331 99495.9696
R4_1331 fb1331 0 21973.5735
Rl1331 out1331 0 10
Vr1332 ref1332 0 0.601657451
E1332 out1332 0 ref1332 fb1332 1e6
R3_1332 out1332 fb1332 100404.425
R4_1332 fb1332 0 22043.0927
Rl1332 out1332 0 10
Vr1333 ref1333 0 0.597435019
E1333 out1333 0 ref1333 fb1333 1e6
R3_1333 out1333 fb1333 99329.3088
R4_1333 fb1333 0 21968.7807
Rl1333 out1333 0 10
Vr1334 ref1334 0 0.592283384
E1334 out1334 0 ref1334 fb1334 1e6
R3_1334 out1334 fb1334 100250.829
R4_1334 fb1334 0 22034.41
Rl1334 out1334 0 10
Vr1335 ref1335 0 0.589506734
E1335 out1335 0 ref1335 fb1335 1e6
R3_1335 out1335 fb1335 99166.0964
R4_1335 fb1335 0 21843.7973
Rl1335 out1335 0 10
Vr1336 ref1336 0 0.594006978
E1336 out1336 0 ref1336 fb1336 1e6
R3_1336 out1336 fb1336 100864.399
R4_1336 fb1336 0 22160.2566
Rl1336 out1336 0 10
Vr1337 ref1337 0 0.597037569
E1337 out1337 0 ref1337 fb1337 1e6
R3_1337 out1337 fb1337 99975.5031
R4_1337 fb1337 0 22207.452
Rl1337 out1337 0 10
Vr1338 ref1338 0 0.598043395
E1338 out1338 0 ref1338 fb1338 1e6
R3_1338 out1338 fb1338 99523.6978
R4_1338 fb1338 0 22178.9858
Rl1338 out1338 0 10
Vr1339 ref1339 0 0.599138672
E1339 out1339 0 ref1339 fb1339 1e6
R3_1339 out1339 fb1339 100068.185
R4_1339 fb1339 0 21786.1979
Rl1339 out1339 0 10
Vr1340 ref1340 0 0.609453326
E1340 out1340 0 ref1340 fb1340 1e6
R3_1340 out1340 fb1340 99238.3846
R4_1340 fb1340 0 22062.9532
Rl1340 out1340 0 10
Vr1341 ref1341 0 0.588987657
E1341 out1341 0 ref1341 fb1341 1e6
R3_1341 out1341 fb1341 99416.7469
R4_1341 fb1341 0 21785.0298
Rl1341 out1341 0 10
Vr1342 ref1342 0 0.60999032
E1342 out1342 0 ref1342 fb1342 1e6
R3_1342 out1342 fb1342 100045.408
R4_1342 fb1342 0 22142.3137
Rl1342 out1342 0 10
Vr1343 ref1343 0 0.600502174
E1343 out1343 0 ref1343 fb1343 1e6
R3_1343 out1343 fb1343 99530.9246
R4_1343 fb1343 0 21896.7841
Rl1343 out1343 0 10
Vr1344 ref1344 0 0.594885214
E1344 out1344 0 ref1344 fb1344 1e6
R3_1344 out1344 fb1344 100834.561
R4_1344 fb1344 0 22078.4656
Rl1344 out1344 0 10
Vr1345 ref1345 0 0.61049206
E1345 out1345 0 ref1345 fb1345 1e6
R3_1345 out1345 fb1345 100567.699
R4_1345 fb1345 0 22001.0699
Rl1345 out1345 0 10
Vr1346 ref1346 0 0.596804749
E1346 out1346 0 ref1346 fb1346 1e6
R3_1346 out1346 fb1346 99099.746
R4_1346 fb1346 0 22091.6764
Rl1346 out1346 0 10
Vr1347 ref1347 0 0.601512728
E1347 out1347 0 ref1347 fb1347 1e6
R3_1347 out1347 fb1347 99323.0697
R4_1347 fb1347 0 21860.3241
Rl1347 out1347 0 10
Vr1348 ref1348 0 0.588671171
E1348 out1348 0 ref1348 fb1348 1e6
R3_1348 out1348 fb1348 100362.062
R4_1348 fb1348 0 22122.5813
Rl1348 out1348 0 10
Vr1349 ref1349 0 0.594594623
E1349 out1349 0 ref1349 fb1349 1e6
R3_1349 out1349 fb1349 100793.54
R4_1349 fb1349 0 21918.1627
Rl1349 out1349 0 10
Vr1350 ref1350 0 0.590473238
E1350 out1350 0 ref1350 fb1350 1e6
R3_1350 out1350 fb1350 99430.9681
R4_1350 fb1350 0 21947.8427
Rl1350 out1350 0 10
Vr1351 ref1351 0 0.597621986
E1351 out1351 0 ref1351 fb1351 1e6
R3_1351 out1351 fb1351 100531.349
R4_1351 fb1351 0 21852.4512
Rl1351 out1351 0 10
Vr1352 ref1352 0 0.594271902
E1352 out1352 0 ref1352 fb1352 1e6
R3_1352 out1352 fb1352 100777.542
R4_1352 fb1352 0 21995.2377
Rl1352 out1352 0 10
Vr1353 ref1353 0 0.592069992
E1353 out1353 0 ref1353 fb1353 1e6
R3_1353 out1353 fb1353 100638.304
R4_1353 fb1353 0 21831.093
Rl1353 out1353 0 10
Vr1354 ref1354 0 0.595975309
E1354 out1354 0 ref1354 fb1354 1e6
R3_1354 out1354 fb1354 99094.2712
R4_1354 fb1354 0 22200.4766
Rl1354 out1354 0 10
Vr1355 ref1355 0 0.605009725
E1355 out1355 0 ref1355 fb1355 1e6
R3_1355 out1355 fb1355 99529.1581
R4_1355 fb1355 0 21934.6552
Rl1355 out1355 0 10
Vr1356 ref1356 0 0.596929378
E1356 out1356 0 ref1356 fb1356 1e6
R3_1356 out1356 fb1356 100502.094
R4_1356 fb1356 0 22021.5176
Rl1356 out1356 0 10
Vr1357 ref1357 0 0.598089876
E1357 out1357 0 ref1357 fb1357 1e6
R3_1357 out1357 fb1357 99403.5881
R4_1357 fb1357 0 21966.6155
Rl1357 out1357 0 10
Vr1358 ref1358 0 0.600959282
E1358 out1358 0 ref1358 fb1358 1e6
R3_1358 out1358 fb1358 99184.3226
R4_1358 fb1358 0 21814.0899
Rl1358 out1358 0 10
Vr1359 ref1359 0 0.610793163
E1359 out1359 0 ref1359 fb1359 1e6
R3_1359 out1359 fb1359 99038.5172
R4_1359 fb1359 0 22167.0451
Rl1359 out1359 0 10
Vr1360 ref1360 0 0.598372976
E1360 out1360 0 ref1360 fb1360 1e6
R3_1360 out1360 fb1360 99318.4855
R4_1360 fb1360 0 21781.088
Rl1360 out1360 0 10
Vr1361 ref1361 0 0.598139342
E1361 out1361 0 ref1361 fb1361 1e6
R3_1361 out1361 fb1361 99466.6189
R4_1361 fb1361 0 22027.9473
Rl1361 out1361 0 10
Vr1362 ref1362 0 0.610233286
E1362 out1362 0 ref1362 fb1362 1e6
R3_1362 out1362 fb1362 100761.664
R4_1362 fb1362 0 21986.47
Rl1362 out1362 0 10
Vr1363 ref1363 0 0.605714406
E1363 out1363 0 ref1363 fb1363 1e6
R3_1363 out1363 fb1363 99316.3225
R4_1363 fb1363 0 22115.8531
Rl1363 out1363 0 10
Vr1364 ref1364 0 0.590777578
E1364 out1364 0 ref1364 fb1364 1e6
R3_1364 out1364 fb1364 99061.93
R4_1364 fb1364 0 22128.3131
Rl1364 out1364 0 10
Vr1365 ref1365 0 0.592825669
E1365 out1365 0 ref1365 fb1365 1e6
R3_1365 out1365 fb1365 99104.1918
R4_1365 fb1365 0 21978.4354
Rl1365 out1365 0 10
Vr1366 ref1366 0 0.601827637
E1366 out1366 0 ref1366 fb1366 1e6
R3_1366 out1366 fb1366 100987.21
R4_1366 fb1366 0 22092.6704
Rl1366 out1366 0 10
Vr1367 ref1367 0 0.605165083
E1367 out1367 0 ref1367 fb1367 1e6
R3_1367 out1367 fb1367 100712.773
R4_1367 fb1367 0 21894.7434
Rl1367 out1367 0 10
Vr1368 ref1368 0 0.596889247
E1368 out1368 0 ref1368 fb1368 1e6
R3_1368 out1368 fb1368 99294.8372
R4_1368 fb1368 0 22199.0261
Rl1368 out1368 0 10
Vr1369 ref1369 0 0.607808622
E1369 out1369 0 ref1369 fb1369 1e6
R3_1369 out1369 fb1369 100229.273
R4_1369 fb1369 0 21784.3122
Rl1369 out1369 0 10
Vr1370 ref1370 0 0.599592495
E1370 out1370 0 ref1370 fb1370 1e6
R3_1370 out1370 fb1370 100403.241
R4_1370 fb1370 0 22037.8085
Rl1370 out1370 0 10
Vr1371 ref1371 0 0.610455329
E1371 out1371 0 ref1371 fb1371 1e6
R3_1371 out1371 fb1371 99799.5774
R4_1371 fb1371 0 21839.4514
Rl1371 out1371 0 10
Vr1372 ref1372 0 0.610823253
E1372 out1372 0 ref1372 fb1372 1e6
R3_1372 out1372 fb1372 99489.5618
R4_1372 fb1372 0 22047.4983
Rl1372 out1372 0 10
Vr1373 ref1373 0 0.606534015
E1373 out1373 0 ref1373 fb1373 1e6
R3_1373 out1373 fb1373 100645.809
R4_1373 fb1373 0 21969.404
Rl1373 out1373 0 10
Vr1374 ref1374 0 0.601613689
E1374 out1374 0 ref1374 fb1374 1e6
R3_1374 out1374 fb1374 99507.5233
R4_1374 fb1374 0 22179.8796
Rl1374 out1374 0 10
Vr1375 ref1375 0 0.606336527
E1375 out1375 0 ref1375 fb1375 1e6
R3_1375 out1375 fb1375 100271.336
R4_1375 fb1375 0 21828.6372
Rl1375 out1375 0 10
Vr1376 ref1376 0 0.597190853
E1376 out1376 0 ref1376 fb1376 1e6
R3_1376 out1376 fb1376 99261.7242
R4_1376 fb1376 0 21861.8916
Rl1376 out1376 0 10
Vr1377 ref1377 0 0.598360747
E1377 out1377 0 ref1377 fb1377 1e6
R3_1377 out1377 fb1377 100022.057
R4_1377 fb1377 0 21842.8263
Rl1377 out1377 0 10
Vr1378 ref1378 0 0.607682959
E1378 out1378 0 ref1378 fb1378 1e6
R3_1378 out1378 fb1378 99011.8915
R4_1378 fb1378 0 21958.3917
Rl1378 out1378 0 10
Vr1379 ref1379 0 0.596955005
E1379 out1379 0 ref1379 fb1379 1e6
R3_1379 out1379 fb1379 100559.013
R4_1379 fb1379 0 22138.8876
Rl1379 out1379 0 10
Vr1380 ref1380 0 0.609782321
E1380 out1380 0 ref1380 fb1380 1e6
R3_1380 out1380 fb1380 100841.737
R4_1380 fb1380 0 21938.7781
Rl1380 out1380 0 10
Vr1381 ref1381 0 0.605352048
E1381 out1381 0 ref1381 fb1381 1e6
R3_1381 out1381 fb1381 99965.6053
R4_1381 fb1381 0 21888.5649
Rl1381 out1381 0 10
Vr1382 ref1382 0 0.606047256
E1382 out1382 0 ref1382 fb1382 1e6
R3_1382 out1382 fb1382 99281.3416
R4_1382 fb1382 0 22095.2802
Rl1382 out1382 0 10
Vr1383 ref1383 0 0.592349103
E1383 out1383 0 ref1383 fb1383 1e6
R3_1383 out1383 fb1383 100146.953
R4_1383 fb1383 0 21828.4169
Rl1383 out1383 0 10
Vr1384 ref1384 0 0.598048062
E1384 out1384 0 ref1384 fb1384 1e6
R3_1384 out1384 fb1384 99532.4187
R4_1384 fb1384 0 22192.818
Rl1384 out1384 0 10
Vr1385 ref1385 0 0.607861214
E1385 out1385 0 ref1385 fb1385 1e6
R3_1385 out1385 fb1385 99477.2386
R4_1385 fb1385 0 21908.6964
Rl1385 out1385 0 10
Vr1386 ref1386 0 0.611139802
E1386 out1386 0 ref1386 fb1386 1e6
R3_1386 out1386 fb1386 99850.6169
R4_1386 fb1386 0 21796.4705
Rl1386 out1386 0 10
Vr1387 ref1387 0 0.59961262
E1387 out1387 0 ref1387 fb1387 1e6
R3_1387 out1387 fb1387 99289.7809
R4_1387 fb1387 0 22187.0793
Rl1387 out1387 0 10
Vr1388 ref1388 0 0.596912431
E1388 out1388 0 ref1388 fb1388 1e6
R3_1388 out1388 fb1388 99213.4776
R4_1388 fb1388 0 22063.6021
Rl1388 out1388 0 10
Vr1389 ref1389 0 0.609853655
E1389 out1389 0 ref1389 fb1389 1e6
R3_1389 out1389 fb1389 99924.2329
R4_1389 fb1389 0 21975.5559
Rl1389 out1389 0 10
Vr1390 ref1390 0 0.598975847
E1390 out1390 0 ref1390 fb1390 1e6
R3_1390 out1390 fb1390 99845.1197
R4_1390 fb1390 0 21896.3925
Rl1390 out1390 0 10
Vr1391 ref1391 0 0.603535141
E1391 out1391 0 ref1391 fb1391 1e6
R3_1391 out1391 fb1391 99669.2093
R4_1391 fb1391 0 21913.7822
Rl1391 out1391 0 10
Vr1392 ref1392 0 0.60607391
E1392 out1392 0 ref1392 fb1392 1e6
R3_1392 out1392 fb1392 99603.3062
R4_1392 fb1392 0 22165.1973
Rl1392 out1392 0 10
Vr1393 ref1393 0 0.593301047
E1393 out1393 0 ref1393 fb1393 1e6
R3_1393 out1393 fb1393 99130.9512
R4_1393 fb1393 0 22016.0906
Rl1393 out1393 0 10
Vr1394 ref1394 0 0.61039766
E1394 out1394 0 ref1394 fb1394 1e6
R3_1394 out1394 fb1394 100281.96
R4_1394 fb1394 0 22195.845
Rl1394 out1394 0 10
Vr1395 ref1395 0 0.59443476
E1395 out1395 0 ref1395 fb1395 1e6
R3_1395 out1395 fb1395 99862.3583
R4_1395 fb1395 0 21805.8566
Rl1395 out1395 0 10
Vr1396 ref1396 0 0.608134588
E1396 out1396 0 ref1396 fb1396 1e6
R3_1396 out1396 fb1396 99740.7274
R4_1396 fb1396 0 22011.6157
Rl1396 out1396 0 10
Vr1397 ref1397 0 0.592385399
E1397 out1397 0 ref1397 fb1397 1e6
R3_1397 out1397 fb1397 99291.2942
R4_1397 fb1397 0 21919.4457
Rl1397 out1397 0 10
Vr1398 ref1398 0 0.597691111
E1398 out1398 0 ref1398 fb1398 1e6
R3_1398 out1398 fb1398 100244.753
R4_1398 fb1398 0 22142.1219
Rl1398 out1398 0 10
Vr1399 ref1399 0 0.602121121
E1399 out1399 0 ref1399 fb1399 1e6
R3_1399 out1399 fb1399 99642.2248
R4_1399 fb1399 0 21790.0153
Rl1399 out1399 0 10
Vr1400 ref1400 0 0.599603666
E1400 out1400 0 ref1400 fb1400 1e6
R3_1400 out1400 fb1400 100769.567
R4_1400 fb1400 0 22151.244
Rl1400 out1400 0 10
Vr1401 ref1401 0 0.590321418
E1401 out1401 0 ref1401 fb1401 1e6
R3_1401 out1401 fb1401 100747.626
R4_1401 fb1401 0 22044.4121
Rl1401 out1401 0 10
Vr1402 ref1402 0 0.589858863
E1402 out1402 0 ref1402 fb1402 1e6
R3_1402 out1402 fb1402 100629.273
R4_1402 fb1402 0 21837.7236
Rl1402 out1402 0 10
Vr1403 ref1403 0 0.604466898
E1403 out1403 0 ref1403 fb1403 1e6
R3_1403 out1403 fb1403 100229.559
R4_1403 fb1403 0 22212.1535
Rl1403 out1403 0 10
Vr1404 ref1404 0 0.590295319
E1404 out1404 0 ref1404 fb1404 1e6
R3_1404 out1404 fb1404 99047.6764
R4_1404 fb1404 0 22183.2413
Rl1404 out1404 0 10
Vr1405 ref1405 0 0.609093234
E1405 out1405 0 ref1405 fb1405 1e6
R3_1405 out1405 fb1405 99565.4248
R4_1405 fb1405 0 21822.5022
Rl1405 out1405 0 10
Vr1406 ref1406 0 0.607999306
E1406 out1406 0 ref1406 fb1406 1e6
R3_1406 out1406 fb1406 100051.372
R4_1406 fb1406 0 22022.8813
Rl1406 out1406 0 10
Vr1407 ref1407 0 0.590903797
E1407 out1407 0 ref1407 fb1407 1e6
R3_1407 out1407 fb1407 99491.6331
R4_1407 fb1407 0 22198.9511
Rl1407 out1407 0 10
Vr1408 ref1408 0 0.591262606
E1408 out1408 0 ref1408 fb1408 1e6
R3_1408 out1408 fb1408 99427.6675
R4_1408 fb1408 0 22102.6343
Rl1408 out1408 0 10
Vr1409 ref1409 0 0.605352315
E1409 out1409 0 ref1409 fb1409 1e6
R3_1409 out1409 fb1409 100420.306
R4_1409 fb1409 0 21874.769
Rl1409 out1409 0 10
Vr1410 ref1410 0 0.609294016
E1410 out1410 0 ref1410 fb1410 1e6
R3_1410 out1410 fb1410 99596.9499
R4_1410 fb1410 0 22092.1249
Rl1410 out1410 0 10
Vr1411 ref1411 0 0.59614403
E1411 out1411 0 ref1411 fb1411 1e6
R3_1411 out1411 fb1411 100379.498
R4_1411 fb1411 0 22043.2267
Rl1411 out1411 0 10
Vr1412 ref1412 0 0.606864865
E1412 out1412 0 ref1412 fb1412 1e6
R3_1412 out1412 fb1412 99796.6555
R4_1412 fb1412 0 22136.6654
Rl1412 out1412 0 10
Vr1413 ref1413 0 0.606945629
E1413 out1413 0 ref1413 fb1413 1e6
R3_1413 out1413 fb1413 100189.036
R4_1413 fb1413 0 22205.2401
Rl1413 out1413 0 10
Vr1414 ref1414 0 0.600268371
E1414 out1414 0 ref1414 fb1414 1e6
R3_1414 out1414 fb1414 99624.9485
R4_1414 fb1414 0 21875.5617
Rl1414 out1414 0 10
Vr1415 ref1415 0 0.590122373
E1415 out1415 0 ref1415 fb1415 1e6
R3_1415 out1415 fb1415 100952.239
R4_1415 fb1415 0 22196.9967
Rl1415 out1415 0 10
Vr1416 ref1416 0 0.595392062
E1416 out1416 0 ref1416 fb1416 1e6
R3_1416 out1416 fb1416 99894.0291
R4_1416 fb1416 0 21888.8876
Rl1416 out1416 0 10
Vr1417 ref1417 0 0.590997204
E1417 out1417 0 ref1417 fb1417 1e6
R3_1417 out1417 fb1417 99281.6089
R4_1417 fb1417 0 21820.8455
Rl1417 out1417 0 10
Vr1418 ref1418 0 0.61011775
E1418 out1418 0 ref1418 fb1418 1e6
R3_1418 out1418 fb1418 99421.1838
R4_1418 fb1418 0 21944.2379
Rl1418 out1418 0 10
Vr1419 ref1419 0 0.60873759
E1419 out1419 0 ref1419 fb1419 1e6
R3_1419 out1419 fb1419 100537.702
R4_1419 fb1419 0 21910.5454
Rl1419 out1419 0 10
Vr1420 ref1420 0 0.598464513
E1420 out1420 0 ref1420 fb1420 1e6
R3_1420 out1420 fb1420 100713.889
R4_1420 fb1420 0 22217.8661
Rl1420 out1420 0 10
Vr1421 ref1421 0 0.607313571
E1421 out1421 0 ref1421 fb1421 1e6
R3_1421 out1421 fb1421 100875.093
R4_1421 fb1421 0 21864.4665
Rl1421 out1421 0 10
Vr1422 ref1422 0 0.610425745
E1422 out1422 0 ref1422 fb1422 1e6
R3_1422 out1422 fb1422 100920.783
R4_1422 fb1422 0 22142.0176
Rl1422 out1422 0 10
Vr1423 ref1423 0 0.60872095
E1423 out1423 0 ref1423 fb1423 1e6
R3_1423 out1423 fb1423 100352.245
R4_1423 fb1423 0 21956.7858
Rl1423 out1423 0 10
Vr1424 ref1424 0 0.595897496
E1424 out1424 0 ref1424 fb1424 1e6
R3_1424 out1424 fb1424 99615.7822
R4_1424 fb1424 0 22214.144
Rl1424 out1424 0 10
Vr1425 ref1425 0 0.597953451
E1425 out1425 0 ref1425 fb1425 1e6
R3_1425 out1425 fb1425 100769.795
R4_1425 fb1425 0 21872.1084
Rl1425 out1425 0 10
Vr1426 ref1426 0 0.599689995
E1426 out1426 0 ref1426 fb1426 1e6
R3_1426 out1426 fb1426 99608.8916
R4_1426 fb1426 0 22140.3033
Rl1426 out1426 0 10
Vr1427 ref1427 0 0.606937411
E1427 out1427 0 ref1427 fb1427 1e6
R3_1427 out1427 fb1427 100292.942
R4_1427 fb1427 0 21790.3564
Rl1427 out1427 0 10
Vr1428 ref1428 0 0.588250805
E1428 out1428 0 ref1428 fb1428 1e6
R3_1428 out1428 fb1428 99587.1291
R4_1428 fb1428 0 22054.1371
Rl1428 out1428 0 10
Vr1429 ref1429 0 0.594137622
E1429 out1429 0 ref1429 fb1429 1e6
R3_1429 out1429 fb1429 100062.111
R4_1429 fb1429 0 21935.3631
Rl1429 out1429 0 10
Vr1430 ref1430 0 0.589714013
E1430 out1430 0 ref1430 fb1430 1e6
R3_1430 out1430 fb1430 99930.7126
R4_1430 fb1430 0 21850.6657
Rl1430 out1430 0 10
Vr1431 ref1431 0 0.609985475
E1431 out1431 0 ref1431 fb1431 1e6
R3_1431 out1431 fb1431 100462.798
R4_1431 fb1431 0 22098.6203
Rl1431 out1431 0 10
Vr1432 ref1432 0 0.603334606
E1432 out1432 0 ref1432 fb1432 1e6
R3_1432 out1432 fb1432 99811.6826
R4_1432 fb1432 0 22005.3749
Rl1432 out1432 0 10
Vr1433 ref1433 0 0.603619484
E1433 out1433 0 ref1433 fb1433 1e6
R3_1433 out1433 fb1433 99957.6329
R4_1433 fb1433 0 22055.0821
Rl1433 out1433 0 10
Vr1434 ref1434 0 0.606030326
E1434 out1434 0 ref1434 fb1434 1e6
R3_1434 out1434 fb1434 100508.165
R4_1434 fb1434 0 22049.9851
Rl1434 out1434 0 10
Vr1435 ref1435 0 0.610947487
E1435 out1435 0 ref1435 fb1435 1e6
R3_1435 out1435 fb1435 99457.4413
R4_1435 fb1435 0 21807.3421
Rl1435 out1435 0 10
Vr1436 ref1436 0 0.610757622
E1436 out1436 0 ref1436 fb1436 1e6
R3_1436 out1436 fb1436 100932.83
R4_1436 fb1436 0 22088.5231
Rl1436 out1436 0 10
Vr1437 ref1437 0 0.599756189
E1437 out1437 0 ref1437 fb1437 1e6
R3_1437 out1437 fb1437 100963.799
R4_1437 fb1437 0 21957.9987
Rl1437 out1437 0 10
Vr1438 ref1438 0 0.5985892
E1438 out1438 0 ref1438 fb1438 1e6
R3_1438 out1438 fb1438 100302.665
R4_1438 fb1438 0 21908.5228
Rl1438 out1438 0 10
Vr1439 ref1439 0 0.610729886
E1439 out1439 0 ref1439 fb1439 1e6
R3_1439 out1439 fb1439 100746.481
R4_1439 fb1439 0 21902.6859
Rl1439 out1439 0 10
Vr1440 ref1440 0 0.606571868
E1440 out1440 0 ref1440 fb1440 1e6
R3_1440 out1440 fb1440 99418.2436
R4_1440 fb1440 0 21798.5713
Rl1440 out1440 0 10
Vr1441 ref1441 0 0.590048108
E1441 out1441 0 ref1441 fb1441 1e6
R3_1441 out1441 fb1441 99628.0697
R4_1441 fb1441 0 21894.5819
Rl1441 out1441 0 10
Vr1442 ref1442 0 0.590724648
E1442 out1442 0 ref1442 fb1442 1e6
R3_1442 out1442 fb1442 100266.249
R4_1442 fb1442 0 22060.6903
Rl1442 out1442 0 10
Vr1443 ref1443 0 0.609095946
E1443 out1443 0 ref1443 fb1443 1e6
R3_1443 out1443 fb1443 100390.872
R4_1443 fb1443 0 21796.0566
Rl1443 out1443 0 10
Vr1444 ref1444 0 0.590070023
E1444 out1444 0 ref1444 fb1444 1e6
R3_1444 out1444 fb1444 100677.34
R4_1444 fb1444 0 22102.0961
Rl1444 out1444 0 10
Vr1445 ref1445 0 0.590087339
E1445 out1445 0 ref1445 fb1445 1e6
R3_1445 out1445 fb1445 100575.437
R4_1445 fb1445 0 21848.1538
Rl1445 out1445 0 10
Vr1446 ref1446 0 0.595656951
E1446 out1446 0 ref1446 fb1446 1e6
R3_1446 out1446 fb1446 100354.591
R4_1446 fb1446 0 21904.7588
Rl1446 out1446 0 10
Vr1447 ref1447 0 0.589686517
E1447 out1447 0 ref1447 fb1447 1e6
R3_1447 out1447 fb1447 100154.438
R4_1447 fb1447 0 21946.1272
Rl1447 out1447 0 10
Vr1448 ref1448 0 0.606963505
E1448 out1448 0 ref1448 fb1448 1e6
R3_1448 out1448 fb1448 99567.3595
R4_1448 fb1448 0 22091.9598
Rl1448 out1448 0 10
Vr1449 ref1449 0 0.608455963
E1449 out1449 0 ref1449 fb1449 1e6
R3_1449 out1449 fb1449 99356.5873
R4_1449 fb1449 0 22039.3701
Rl1449 out1449 0 10
Vr1450 ref1450 0 0.601814178
E1450 out1450 0 ref1450 fb1450 1e6
R3_1450 out1450 fb1450 99225.7569
R4_1450 fb1450 0 22190.9786
Rl1450 out1450 0 10
Vr1451 ref1451 0 0.593827235
E1451 out1451 0 ref1451 fb1451 1e6
R3_1451 out1451 fb1451 99024.4681
R4_1451 fb1451 0 21936.2616
Rl1451 out1451 0 10
Vr1452 ref1452 0 0.589580247
E1452 out1452 0 ref1452 fb1452 1e6
R3_1452 out1452 fb1452 99284.8622
R4_1452 fb1452 0 22072.1126
Rl1452 out1452 0 10
Vr1453 ref1453 0 0.611364373
E1453 out1453 0 ref1453 fb1453 1e6
R3_1453 out1453 fb1453 99622.6511
R4_1453 fb1453 0 21998.8481
Rl1453 out1453 0 10
Vr1454 ref1454 0 0.592544655
E1454 out1454 0 ref1454 fb1454 1e6
R3_1454 out1454 fb1454 100229.303
R4_1454 fb1454 0 21984.5904
Rl1454 out1454 0 10
Vr1455 ref1455 0 0.603214512
E1455 out1455 0 ref1455 fb1455 1e6
R3_1455 out1455 fb1455 99613.7765
R4_1455 fb1455 0 21855.3196
Rl1455 out1455 0 10
Vr1456 ref1456 0 0.60566581
E1456 out1456 0 ref1456 fb1456 1e6
R3_1456 out1456 fb1456 100166.69
R4_1456 fb1456 0 22039.1243
Rl1456 out1456 0 10
Vr1457 ref1457 0 0.607274199
E1457 out1457 0 ref1457 fb1457 1e6
R3_1457 out1457 fb1457 100874.559
R4_1457 fb1457 0 21784.2715
Rl1457 out1457 0 10
Vr1458 ref1458 0 0.610316027
E1458 out1458 0 ref1458 fb1458 1e6
R3_1458 out1458 fb1458 99049.5119
R4_1458 fb1458 0 21975.8195
Rl1458 out1458 0 10
Vr1459 ref1459 0 0.603197031
E1459 out1459 0 ref1459 fb1459 1e6
R3_1459 out1459 fb1459 99451.3775
R4_1459 fb1459 0 21830.7116
Rl1459 out1459 0 10
Vr1460 ref1460 0 0.597069785
E1460 out1460 0 ref1460 fb1460 1e6
R3_1460 out1460 fb1460 100916.885
R4_1460 fb1460 0 21988.5891
Rl1460 out1460 0 10
Vr1461 ref1461 0 0.607362507
E1461 out1461 0 ref1461 fb1461 1e6
R3_1461 out1461 fb1461 100195.186
R4_1461 fb1461 0 21905.5412
Rl1461 out1461 0 10
Vr1462 ref1462 0 0.602736491
E1462 out1462 0 ref1462 fb1462 1e6
R3_1462 out1462 fb1462 99148.1402
R4_1462 fb1462 0 22042.4619
Rl1462 out1462 0 10
Vr1463 ref1463 0 0.602364531
E1463 out1463 0 ref1463 fb1463 1e6
R3_1463 out1463 fb1463 100764.407
R4_1463 fb1463 0 22128.1272
Rl1463 out1463 0 10
Vr1464 ref1464 0 0.595541052
E1464 out1464 0 ref1464 fb1464 1e6
R3_1464 out1464 fb1464 99295.4706
R4_1464 fb1464 0 22016.369
Rl1464 out1464 0 10
Vr1465 ref1465 0 0.590926005
E1465 out1465 0 ref1465 fb1465 1e6
R3_1465 out1465 fb1465 100518.588
R4_1465 fb1465 0 21957.8944
Rl1465 out1465 0 10
Vr1466 ref1466 0 0.596961589
E1466 out1466 0 ref1466 fb1466 1e6
R3_1466 out1466 fb1466 99517.7437
R4_1466 fb1466 0 22085.6354
Rl1466 out1466 0 10
Vr1467 ref1467 0 0.603757096
E1467 out1467 0 ref1467 fb1467 1e6
R3_1467 out1467 fb1467 99749.0409
R4_1467 fb1467 0 22082.6731
Rl1467 out1467 0 10
Vr1468 ref1468 0 0.589814063
E1468 out1468 0 ref1468 fb1468 1e6
R3_1468 out1468 fb1468 99570.9234
R4_1468 fb1468 0 21859.3768
Rl1468 out1468 0 10
Vr1469 ref1469 0 0.600887298
E1469 out1469 0 ref1469 fb1469 1e6
R3_1469 out1469 fb1469 99814.8055
R4_1469 fb1469 0 22003.6013
Rl1469 out1469 0 10
Vr1470 ref1470 0 0.588484479
E1470 out1470 0 ref1470 fb1470 1e6
R3_1470 out1470 fb1470 99466.8301
R4_1470 fb1470 0 21978.7503
Rl1470 out1470 0 10
Vr1471 ref1471 0 0.601204838
E1471 out1471 0 ref1471 fb1471 1e6
R3_1471 out1471 fb1471 100543.522
R4_1471 fb1471 0 22015.8613
Rl1471 out1471 0 10
Vr1472 ref1472 0 0.603935576
E1472 out1472 0 ref1472 fb1472 1e6
R3_1472 out1472 fb1472 100038.371
R4_1472 fb1472 0 22163.4796
Rl1472 out1472 0 10
Vr1473 ref1473 0 0.597298605
E1473 out1473 0 ref1473 fb1473 1e6
R3_1473 out1473 fb1473 100065.492
R4_1473 fb1473 0 22138.1104
Rl1473 out1473 0 10
Vr1474 ref1474 0 0.596741796
E1474 out1474 0 ref1474 fb1474 1e6
R3_1474 out1474 fb1474 99972.4829
R4_1474 fb1474 0 22099.5748
Rl1474 out1474 0 10
Vr1475 ref1475 0 0.599005381
E1475 out1475 0 ref1475 fb1475 1e6
R3_1475 out1475 fb1475 99648.7486
R4_1475 fb1475 0 22206.7666
Rl1475 out1475 0 10
Vr1476 ref1476 0 0.589098735
E1476 out1476 0 ref1476 fb1476 1e6
R3_1476 out1476 fb1476 100279.036
R4_1476 fb1476 0 21823.7037
Rl1476 out1476 0 10
Vr1477 ref1477 0 0.611780999
E1477 out1477 0 ref1477 fb1477 1e6
R3_1477 out1477 fb1477 100694.059
R4_1477 fb1477 0 21966.6104
Rl1477 out1477 0 10
Vr1478 ref1478 0 0.593128313
E1478 out1478 0 ref1478 fb1478 1e6
R3_1478 out1478 fb1478 100093.8
R4_1478 fb1478 0 22092.2934
Rl1478 out1478 0 10
Vr1479 ref1479 0 0.594778169
E1479 out1479 0 ref1479 fb1479 1e6
R3_1479 out1479 fb1479 99265.6024
R4_1479 fb1479 0 21854.0441
Rl1479 out1479 0 10
Vr1480 ref1480 0 0.605204807
E1480 out1480 0 ref1480 fb1480 1e6
R3_1480 out1480 fb1480 100475.502
R4_1480 fb1480 0 21956.3231
Rl1480 out1480 0 10
Vr1481 ref1481 0 0.596438053
E1481 out1481 0 ref1481 fb1481 1e6
R3_1481 out1481 fb1481 100084.167
R4_1481 fb1481 0 22065.6851
Rl1481 out1481 0 10
Vr1482 ref1482 0 0.590706749
E1482 out1482 0 ref1482 fb1482 1e6
R3_1482 out1482 fb1482 99596.1085
R4_1482 fb1482 0 22180.5527
Rl1482 out1482 0 10
Vr1483 ref1483 0 0.59148509
E1483 out1483 0 ref1483 fb1483 1e6
R3_1483 out1483 fb1483 100375.342
R4_1483 fb1483 0 22049.4652
Rl1483 out1483 0 10
Vr1484 ref1484 0 0.588774295
E1484 out1484 0 ref1484 fb1484 1e6
R3_1484 out1484 fb1484 100570.885
R4_1484 fb1484 0 21884.1792
Rl1484 out1484 0 10
Vr1485 ref1485 0 0.600877913
E1485 out1485 0 ref1485 fb1485 1e6
R3_1485 out1485 fb1485 100914.147
R4_1485 fb1485 0 22164.6486
Rl1485 out1485 0 10
Vr1486 ref1486 0 0.60156895
E1486 out1486 0 ref1486 fb1486 1e6
R3_1486 out1486 fb1486 99036.5021
R4_1486 fb1486 0 21956.1716
Rl1486 out1486 0 10
Vr1487 ref1487 0 0.600632711
E1487 out1487 0 ref1487 fb1487 1e6
R3_1487 out1487 fb1487 100021.467
R4_1487 fb1487 0 21946.2575
Rl1487 out1487 0 10
Vr1488 ref1488 0 0.609414306
E1488 out1488 0 ref1488 fb1488 1e6
R3_1488 out1488 fb1488 100113.579
R4_1488 fb1488 0 22151.8934
Rl1488 out1488 0 10
Vr1489 ref1489 0 0.59769367
E1489 out1489 0 ref1489 fb1489 1e6
R3_1489 out1489 fb1489 100894
R4_1489 fb1489 0 22019.6838
Rl1489 out1489 0 10
Vr1490 ref1490 0 0.603758559
E1490 out1490 0 ref1490 fb1490 1e6
R3_1490 out1490 fb1490 100767.984
R4_1490 fb1490 0 22131.8359
Rl1490 out1490 0 10
Vr1491 ref1491 0 0.611339421
E1491 out1491 0 ref1491 fb1491 1e6
R3_1491 out1491 fb1491 100823.044
R4_1491 fb1491 0 22043.7855
Rl1491 out1491 0 10
Vr1492 ref1492 0 0.598911005
E1492 out1492 0 ref1492 fb1492 1e6
R3_1492 out1492 fb1492 99928.3981
R4_1492 fb1492 0 22122.4144
Rl1492 out1492 0 10
Vr1493 ref1493 0 0.601048197
E1493 out1493 0 ref1493 fb1493 1e6
R3_1493 out1493 fb1493 100291.709
R4_1493 fb1493 0 21982.734
Rl1493 out1493 0 10
Vr1494 ref1494 0 0.589509207
E1494 out1494 0 ref1494 fb1494 1e6
R3_1494 out1494 fb1494 99332.8378
R4_1494 fb1494 0 22024.1142
Rl1494 out1494 0 10
Vr1495 ref1495 0 0.590949105
E1495 out1495 0 ref1495 fb1495 1e6
R3_1495 out1495 fb1495 100340.578
R4_1495 fb1495 0 22216.4105
Rl1495 out1495 0 10
Vr1496 ref1496 0 0.593484196
E1496 out1496 0 ref1496 fb1496 1e6
R3_1496 out1496 fb1496 99307.1631
R4_1496 fb1496 0 22195.3629
Rl1496 out1496 0 10
Vr1497 ref1497 0 0.597224925
E1497 out1497 0 ref1497 fb1497 1e6
R3_1497 out1497 fb1497 100532.537
R4_1497 fb1497 0 21909.397
Rl1497 out1497 0 10
Vr1498 ref1498 0 0.592854862
E1498 out1498 0 ref1498 fb1498 1e6
R3_1498 out1498 fb1498 100491.485
R4_1498 fb1498 0 21875.6524
Rl1498 out1498 0 10
Vr1499 ref1499 0 0.60232228
E1499 out1499 0 ref1499 fb1499 1e6
R3_1499 out1499 fb1499 100258.886
R4_1499 fb1499 0 22155.1998
Rl1499 out1499 0 10
Vr1500 ref1500 0 0.600871171
E1500 out1500 0 ref1500 fb1500 1e6
R3_1500 out1500 fb1500 99481.6255
R4_1500 fb1500 0 22042.8267
Rl1500 out1500 0 10
Vr1501 ref1501 0 0.604483657
E1501 out1501 0 ref1501 fb1501 1e6
R3_1501 out1501 fb1501 100299.894
R4_1501 fb1501 0 21870.0602
Rl1501 out1501 0 10
Vr1502 ref1502 0 0.605670048
E1502 out1502 0 ref1502 fb1502 1e6
R3_1502 out1502 fb1502 99270.2844
R4_1502 fb1502 0 21853.7551
Rl1502 out1502 0 10
Vr1503 ref1503 0 0.591719883
E1503 out1503 0 ref1503 fb1503 1e6
R3_1503 out1503 fb1503 99684.5749
R4_1503 fb1503 0 21844.941
Rl1503 out1503 0 10
Vr1504 ref1504 0 0.607935139
E1504 out1504 0 ref1504 fb1504 1e6
R3_1504 out1504 fb1504 100185.547
R4_1504 fb1504 0 22121.5765
Rl1504 out1504 0 10
Vr1505 ref1505 0 0.592258846
E1505 out1505 0 ref1505 fb1505 1e6
R3_1505 out1505 fb1505 99769.8109
R4_1505 fb1505 0 21825.7069
Rl1505 out1505 0 10
Vr1506 ref1506 0 0.609591073
E1506 out1506 0 ref1506 fb1506 1e6
R3_1506 out1506 fb1506 99552.4539
R4_1506 fb1506 0 22048.6413
Rl1506 out1506 0 10
Vr1507 ref1507 0 0.597061772
E1507 out1507 0 ref1507 fb1507 1e6
R3_1507 out1507 fb1507 99078.3854
R4_1507 fb1507 0 21970.0681
Rl1507 out1507 0 10
Vr1508 ref1508 0 0.600815364
E1508 out1508 0 ref1508 fb1508 1e6
R3_1508 out1508 fb1508 100250.304
R4_1508 fb1508 0 21927.5943
Rl1508 out1508 0 10
Vr1509 ref1509 0 0.58829533
E1509 out1509 0 ref1509 fb1509 1e6
R3_1509 out1509 fb1509 99918.883
R4_1509 fb1509 0 22191.4305
Rl1509 out1509 0 10
Vr1510 ref1510 0 0.59826954
E1510 out1510 0 ref1510 fb1510 1e6
R3_1510 out1510 fb1510 99199.4119
R4_1510 fb1510 0 21972.6789
Rl1510 out1510 0 10
Vr1511 ref1511 0 0.59507362
E1511 out1511 0 ref1511 fb1511 1e6
R3_1511 out1511 fb1511 99939.9934
R4_1511 fb1511 0 21820.03
Rl1511 out1511 0 10
Vr1512 ref1512 0 0.599680287
E1512 out1512 0 ref1512 fb1512 1e6
R3_1512 out1512 fb1512 99021.3854
R4_1512 fb1512 0 21856.8106
Rl1512 out1512 0 10
Vr1513 ref1513 0 0.597949896
E1513 out1513 0 ref1513 fb1513 1e6
R3_1513 out1513 fb1513 99477.2867
R4_1513 fb1513 0 22204.3753
Rl1513 out1513 0 10
Vr1514 ref1514 0 0.594595092
E1514 out1514 0 ref1514 fb1514 1e6
R3_1514 out1514 fb1514 100033.505
R4_1514 fb1514 0 21999.7476
Rl1514 out1514 0 10
Vr1515 ref1515 0 0.590940575
E1515 out1515 0 ref1515 fb1515 1e6
R3_1515 out1515 fb1515 100547.433
R4_1515 fb1515 0 22096.9393
Rl1515 out1515 0 10
Vr1516 ref1516 0 0.597687406
E1516 out1516 0 ref1516 fb1516 1e6
R3_1516 out1516 fb1516 100857.336
R4_1516 fb1516 0 21911.8828
Rl1516 out1516 0 10
Vr1517 ref1517 0 0.607818891
E1517 out1517 0 ref1517 fb1517 1e6
R3_1517 out1517 fb1517 100056.096
R4_1517 fb1517 0 21797.0962
Rl1517 out1517 0 10
Vr1518 ref1518 0 0.588284004
E1518 out1518 0 ref1518 fb1518 1e6
R3_1518 out1518 fb1518 100876.139
R4_1518 fb1518 0 22142.1213
Rl1518 out1518 0 10
Vr1519 ref1519 0 0.598448506
E1519 out1519 0 ref1519 fb1519 1e6
R3_1519 out1519 fb1519 100573.6
R4_1519 fb1519 0 21789.2522
Rl1519 out1519 0 10
Vr1520 ref1520 0 0.602211226
E1520 out1520 0 ref1520 fb1520 1e6
R3_1520 out1520 fb1520 100402.971
R4_1520 fb1520 0 22040.1773
Rl1520 out1520 0 10
Vr1521 ref1521 0 0.601349753
E1521 out1521 0 ref1521 fb1521 1e6
R3_1521 out1521 fb1521 100604.573
R4_1521 fb1521 0 21982.0154
Rl1521 out1521 0 10
Vr1522 ref1522 0 0.592227618
E1522 out1522 0 ref1522 fb1522 1e6
R3_1522 out1522 fb1522 100447.122
R4_1522 fb1522 0 22148.3698
Rl1522 out1522 0 10
Vr1523 ref1523 0 0.607088414
E1523 out1523 0 ref1523 fb1523 1e6
R3_1523 out1523 fb1523 99118.869
R4_1523 fb1523 0 21900.7315
Rl1523 out1523 0 10
Vr1524 ref1524 0 0.597698874
E1524 out1524 0 ref1524 fb1524 1e6
R3_1524 out1524 fb1524 99204.7033
R4_1524 fb1524 0 22128.3812
Rl1524 out1524 0 10
Vr1525 ref1525 0 0.589232261
E1525 out1525 0 ref1525 fb1525 1e6
R3_1525 out1525 fb1525 100254.194
R4_1525 fb1525 0 22072.5098
Rl1525 out1525 0 10
Vr1526 ref1526 0 0.597939021
E1526 out1526 0 ref1526 fb1526 1e6
R3_1526 out1526 fb1526 100496.988
R4_1526 fb1526 0 21890.7508
Rl1526 out1526 0 10
Vr1527 ref1527 0 0.600453063
E1527 out1527 0 ref1527 fb1527 1e6
R3_1527 out1527 fb1527 100053.096
R4_1527 fb1527 0 21845.5167
Rl1527 out1527 0 10
Vr1528 ref1528 0 0.600376761
E1528 out1528 0 ref1528 fb1528 1e6
R3_1528 out1528 fb1528 99210.3072
R4_1528 fb1528 0 21977.7732
Rl1528 out1528 0 10
Vr1529 ref1529 0 0.598843034
E1529 out1529 0 ref1529 fb1529 1e6
R3_1529 out1529 fb1529 100882.965
R4_1529 fb1529 0 22109.8661
Rl1529 out1529 0 10
Vr1530 ref1530 0 0.588759793
E1530 out1530 0 ref1530 fb1530 1e6
R3_1530 out1530 fb1530 100467.703
R4_1530 fb1530 0 21974.2353
Rl1530 out1530 0 10
Vr1531 ref1531 0 0.608574926
E1531 out1531 0 ref1531 fb1531 1e6
R3_1531 out1531 fb1531 100674.334
R4_1531 fb1531 0 22156.6634
Rl1531 out1531 0 10
Vr1532 ref1532 0 0.593485777
E1532 out1532 0 ref1532 fb1532 1e6
R3_1532 out1532 fb1532 100639.423
R4_1532 fb1532 0 21915.2926
Rl1532 out1532 0 10
Vr1533 ref1533 0 0.596856345
E1533 out1533 0 ref1533 fb1533 1e6
R3_1533 out1533 fb1533 100540.069
R4_1533 fb1533 0 21996.7015
Rl1533 out1533 0 10
Vr1534 ref1534 0 0.611041235
E1534 out1534 0 ref1534 fb1534 1e6
R3_1534 out1534 fb1534 99397.6316
R4_1534 fb1534 0 21830.6647
Rl1534 out1534 0 10
Vr1535 ref1535 0 0.594465076
E1535 out1535 0 ref1535 fb1535 1e6
R3_1535 out1535 fb1535 99770.8927
R4_1535 fb1535 0 21893.3563
Rl1535 out1535 0 10
Vr1536 ref1536 0 0.595743607
E1536 out1536 0 ref1536 fb1536 1e6
R3_1536 out1536 fb1536 99418.0214
R4_1536 fb1536 0 21889.6186
Rl1536 out1536 0 10
Vr1537 ref1537 0 0.597922533
E1537 out1537 0 ref1537 fb1537 1e6
R3_1537 out1537 fb1537 100836.697
R4_1537 fb1537 0 21832.4877
Rl1537 out1537 0 10
Vr1538 ref1538 0 0.588874088
E1538 out1538 0 ref1538 fb1538 1e6
R3_1538 out1538 fb1538 99485.245
R4_1538 fb1538 0 21993.4508
Rl1538 out1538 0 10
Vr1539 ref1539 0 0.601949722
E1539 out1539 0 ref1539 fb1539 1e6
R3_1539 out1539 fb1539 99836.5621
R4_1539 fb1539 0 22218.4286
Rl1539 out1539 0 10
Vr1540 ref1540 0 0.601386104
E1540 out1540 0 ref1540 fb1540 1e6
R3_1540 out1540 fb1540 99919.4562
R4_1540 fb1540 0 22027.3258
Rl1540 out1540 0 10
Vr1541 ref1541 0 0.611769931
E1541 out1541 0 ref1541 fb1541 1e6
R3_1541 out1541 fb1541 99185.2737
R4_1541 fb1541 0 22143.2621
Rl1541 out1541 0 10
Vr1542 ref1542 0 0.60030242
E1542 out1542 0 ref1542 fb1542 1e6
R3_1542 out1542 fb1542 99904.9264
R4_1542 fb1542 0 21962.0097
Rl1542 out1542 0 10
Vr1543 ref1543 0 0.597884197
E1543 out1543 0 ref1543 fb1543 1e6
R3_1543 out1543 fb1543 99456.8452
R4_1543 fb1543 0 22076.1971
Rl1543 out1543 0 10
Vr1544 ref1544 0 0.604536132
E1544 out1544 0 ref1544 fb1544 1e6
R3_1544 out1544 fb1544 99202.6171
R4_1544 fb1544 0 22162.0619
Rl1544 out1544 0 10
Vr1545 ref1545 0 0.607411777
E1545 out1545 0 ref1545 fb1545 1e6
R3_1545 out1545 fb1545 100254.324
R4_1545 fb1545 0 22056.7037
Rl1545 out1545 0 10
Vr1546 ref1546 0 0.603128127
E1546 out1546 0 ref1546 fb1546 1e6
R3_1546 out1546 fb1546 100698.336
R4_1546 fb1546 0 22034.5333
Rl1546 out1546 0 10
Vr1547 ref1547 0 0.599378785
E1547 out1547 0 ref1547 fb1547 1e6
R3_1547 out1547 fb1547 99212.6345
R4_1547 fb1547 0 22076.5791
Rl1547 out1547 0 10
Vr1548 ref1548 0 0.607322842
E1548 out1548 0 ref1548 fb1548 1e6
R3_1548 out1548 fb1548 100080.267
R4_1548 fb1548 0 22193.714
Rl1548 out1548 0 10
Vr1549 ref1549 0 0.599683313
E1549 out1549 0 ref1549 fb1549 1e6
R3_1549 out1549 fb1549 99463.9077
R4_1549 fb1549 0 22186.9082
Rl1549 out1549 0 10
Vr1550 ref1550 0 0.598471943
E1550 out1550 0 ref1550 fb1550 1e6
R3_1550 out1550 fb1550 99930.3402
R4_1550 fb1550 0 21997.4381
Rl1550 out1550 0 10
Vr1551 ref1551 0 0.589440652
E1551 out1551 0 ref1551 fb1551 1e6
R3_1551 out1551 fb1551 99628.5265
R4_1551 fb1551 0 21882.8552
Rl1551 out1551 0 10
Vr1552 ref1552 0 0.610084533
E1552 out1552 0 ref1552 fb1552 1e6
R3_1552 out1552 fb1552 100047.09
R4_1552 fb1552 0 22079.6147
Rl1552 out1552 0 10
Vr1553 ref1553 0 0.596778159
E1553 out1553 0 ref1553 fb1553 1e6
R3_1553 out1553 fb1553 100750.471
R4_1553 fb1553 0 21848.9565
Rl1553 out1553 0 10
Vr1554 ref1554 0 0.597784742
E1554 out1554 0 ref1554 fb1554 1e6
R3_1554 out1554 fb1554 99752.0814
R4_1554 fb1554 0 22179.0331
Rl1554 out1554 0 10
Vr1555 ref1555 0 0.611993754
E1555 out1555 0 ref1555 fb1555 1e6
R3_1555 out1555 fb1555 100343.752
R4_1555 fb1555 0 22038.5943
Rl1555 out1555 0 10
Vr1556 ref1556 0 0.595276128
E1556 out1556 0 ref1556 fb1556 1e6
R3_1556 out1556 fb1556 100164.651
R4_1556 fb1556 0 21869.2195
Rl1556 out1556 0 10
Vr1557 ref1557 0 0.588817469
E1557 out1557 0 ref1557 fb1557 1e6
R3_1557 out1557 fb1557 100389.431
R4_1557 fb1557 0 22006.3381
Rl1557 out1557 0 10
Vr1558 ref1558 0 0.601288376
E1558 out1558 0 ref1558 fb1558 1e6
R3_1558 out1558 fb1558 99924.2378
R4_1558 fb1558 0 21848.1765
Rl1558 out1558 0 10
Vr1559 ref1559 0 0.606077468
E1559 out1559 0 ref1559 fb1559 1e6
R3_1559 out1559 fb1559 99197.1398
R4_1559 fb1559 0 21960.2944
Rl1559 out1559 0 10
Vr1560 ref1560 0 0.610194542
E1560 out1560 0 ref1560 fb1560 1e6
R3_1560 out1560 fb1560 100187.889
R4_1560 fb1560 0 21791.0746
Rl1560 out1560 0 10
Vr1561 ref1561 0 0.595171816
E1561 out1561 0 ref1561 fb1561 1e6
R3_1561 out1561 fb1561 100489.683
R4_1561 fb1561 0 21790.2122
Rl1561 out1561 0 10
Vr1562 ref1562 0 0.589661335
E1562 out1562 0 ref1562 fb1562 1e6
R3_1562 out1562 fb1562 99821.9503
R4_1562 fb1562 0 21818.8321
Rl1562 out1562 0 10
Vr1563 ref1563 0 0.594042736
E1563 out1563 0 ref1563 fb1563 1e6
R3_1563 out1563 fb1563 99491.227
R4_1563 fb1563 0 22125.0363
Rl1563 out1563 0 10
Vr1564 ref1564 0 0.599966149
E1564 out1564 0 ref1564 fb1564 1e6
R3_1564 out1564 fb1564 100830.839
R4_1564 fb1564 0 22185.5182
Rl1564 out1564 0 10
Vr1565 ref1565 0 0.596939684
E1565 out1565 0 ref1565 fb1565 1e6
R3_1565 out1565 fb1565 99638.4523
R4_1565 fb1565 0 21801.3412
Rl1565 out1565 0 10
Vr1566 ref1566 0 0.603672435
E1566 out1566 0 ref1566 fb1566 1e6
R3_1566 out1566 fb1566 99640.008
R4_1566 fb1566 0 22030.1605
Rl1566 out1566 0 10
Vr1567 ref1567 0 0.59948232
E1567 out1567 0 ref1567 fb1567 1e6
R3_1567 out1567 fb1567 100990.236
R4_1567 fb1567 0 21840.9225
Rl1567 out1567 0 10
Vr1568 ref1568 0 0.602280539
E1568 out1568 0 ref1568 fb1568 1e6
R3_1568 out1568 fb1568 100656.122
R4_1568 fb1568 0 22102.5672
Rl1568 out1568 0 10
Vr1569 ref1569 0 0.598520462
E1569 out1569 0 ref1569 fb1569 1e6
R3_1569 out1569 fb1569 99063.6582
R4_1569 fb1569 0 21894.3031
Rl1569 out1569 0 10
Vr1570 ref1570 0 0.604741739
E1570 out1570 0 ref1570 fb1570 1e6
R3_1570 out1570 fb1570 100767.718
R4_1570 fb1570 0 21797.1376
Rl1570 out1570 0 10
Vr1571 ref1571 0 0.609252769
E1571 out1571 0 ref1571 fb1571 1e6
R3_1571 out1571 fb1571 99979.9152
R4_1571 fb1571 0 22060.1055
Rl1571 out1571 0 10
Vr1572 ref1572 0 0.593809307
E1572 out1572 0 ref1572 fb1572 1e6
R3_1572 out1572 fb1572 100795.055
R4_1572 fb1572 0 22088.7984
Rl1572 out1572 0 10
Vr1573 ref1573 0 0.596996225
E1573 out1573 0 ref1573 fb1573 1e6
R3_1573 out1573 fb1573 99453.6592
R4_1573 fb1573 0 21846.9248
Rl1573 out1573 0 10
Vr1574 ref1574 0 0.591692821
E1574 out1574 0 ref1574 fb1574 1e6
R3_1574 out1574 fb1574 99471.8122
R4_1574 fb1574 0 21969.8892
Rl1574 out1574 0 10
Vr1575 ref1575 0 0.592571099
E1575 out1575 0 ref1575 fb1575 1e6
R3_1575 out1575 fb1575 100050.392
R4_1575 fb1575 0 22013.4046
Rl1575 out1575 0 10
Vr1576 ref1576 0 0.595915604
E1576 out1576 0 ref1576 fb1576 1e6
R3_1576 out1576 fb1576 99849.271
R4_1576 fb1576 0 21817.7906
Rl1576 out1576 0 10
Vr1577 ref1577 0 0.588402442
E1577 out1577 0 ref1577 fb1577 1e6
R3_1577 out1577 fb1577 99981.9583
R4_1577 fb1577 0 21809.2894
Rl1577 out1577 0 10
Vr1578 ref1578 0 0.604493835
E1578 out1578 0 ref1578 fb1578 1e6
R3_1578 out1578 fb1578 99476.6676
R4_1578 fb1578 0 21855.2804
Rl1578 out1578 0 10
Vr1579 ref1579 0 0.588745086
E1579 out1579 0 ref1579 fb1579 1e6
R3_1579 out1579 fb1579 100004.756
R4_1579 fb1579 0 21823.719
Rl1579 out1579 0 10
Vr1580 ref1580 0 0.591599691
E1580 out1580 0 ref1580 fb1580 1e6
R3_1580 out1580 fb1580 99947.2752
R4_1580 fb1580 0 22110.588
Rl1580 out1580 0 10
Vr1581 ref1581 0 0.603245007
E1581 out1581 0 ref1581 fb1581 1e6
R3_1581 out1581 fb1581 99029.2629
R4_1581 fb1581 0 21914.7606
Rl1581 out1581 0 10
Vr1582 ref1582 0 0.60496124
E1582 out1582 0 ref1582 fb1582 1e6
R3_1582 out1582 fb1582 100026.609
R4_1582 fb1582 0 22212.4452
Rl1582 out1582 0 10
Vr1583 ref1583 0 0.590664413
E1583 out1583 0 ref1583 fb1583 1e6
R3_1583 out1583 fb1583 100039.45
R4_1583 fb1583 0 22178.134
Rl1583 out1583 0 10
Vr1584 ref1584 0 0.596746516
E1584 out1584 0 ref1584 fb1584 1e6
R3_1584 out1584 fb1584 100209.669
R4_1584 fb1584 0 21841.7899
Rl1584 out1584 0 10
Vr1585 ref1585 0 0.588812622
E1585 out1585 0 ref1585 fb1585 1e6
R3_1585 out1585 fb1585 100717.455
R4_1585 fb1585 0 22073.6941
Rl1585 out1585 0 10
Vr1586 ref1586 0 0.589631215
E1586 out1586 0 ref1586 fb1586 1e6
R3_1586 out1586 fb1586 99184.8077
R4_1586 fb1586 0 21859.0764
Rl1586 out1586 0 10
Vr1587 ref1587 0 0.590408485
E1587 out1587 0 ref1587 fb1587 1e6
R3_1587 out1587 fb1587 100796.253
R4_1587 fb1587 0 21853.6441
Rl1587 out1587 0 10
Vr1588 ref1588 0 0.603463952
E1588 out1588 0 ref1588 fb1588 1e6
R3_1588 out1588 fb1588 100684.598
R4_1588 fb1588 0 22206.1798
Rl1588 out1588 0 10
Vr1589 ref1589 0 0.594664592
E1589 out1589 0 ref1589 fb1589 1e6
R3_1589 out1589 fb1589 100104.677
R4_1589 fb1589 0 22157.4355
Rl1589 out1589 0 10
Vr1590 ref1590 0 0.603407626
E1590 out1590 0 ref1590 fb1590 1e6
R3_1590 out1590 fb1590 100399.269
R4_1590 fb1590 0 22144.7617
Rl1590 out1590 0 10
Vr1591 ref1591 0 0.595981216
E1591 out1591 0 ref1591 fb1591 1e6
R3_1591 out1591 fb1591 100817.594
R4_1591 fb1591 0 21983.6134
Rl1591 out1591 0 10
Vr1592 ref1592 0 0.588347736
E1592 out1592 0 ref1592 fb1592 1e6
R3_1592 out1592 fb1592 100336.966
R4_1592 fb1592 0 21922.8977
Rl1592 out1592 0 10
Vr1593 ref1593 0 0.596838369
E1593 out1593 0 ref1593 fb1593 1e6
R3_1593 out1593 fb1593 99953.0798
R4_1593 fb1593 0 21953.2674
Rl1593 out1593 0 10
Vr1594 ref1594 0 0.601676454
E1594 out1594 0 ref1594 fb1594 1e6
R3_1594 out1594 fb1594 100285.922
R4_1594 fb1594 0 21781.1873
Rl1594 out1594 0 10
Vr1595 ref1595 0 0.58893099
E1595 out1595 0 ref1595 fb1595 1e6
R3_1595 out1595 fb1595 100230.945
R4_1595 fb1595 0 21947.2838
Rl1595 out1595 0 10
Vr1596 ref1596 0 0.593351547
E1596 out1596 0 ref1596 fb1596 1e6
R3_1596 out1596 fb1596 99954.3567
R4_1596 fb1596 0 21987.5916
Rl1596 out1596 0 10
Vr1597 ref1597 0 0.604280601
E1597 out1597 0 ref1597 fb1597 1e6
R3_1597 out1597 fb1597 99326.3557
R4_1597 fb1597 0 21867.042
Rl1597 out1597 0 10
Vr1598 ref1598 0 0.588638007
E1598 out1598 0 ref1598 fb1598 1e6
R3_1598 out1598 fb1598 100902.949
R4_1598 fb1598 0 22199.5297
Rl1598 out1598 0 10
Vr1599 ref1599 0 0.591806662
E1599 out1599 0 ref1599 fb1599 1e6
R3_1599 out1599 fb1599 99543.8058
R4_1599 fb1599 0 22055.6328
Rl1599 out1599 0 10
Vr1600 ref1600 0 0.597681186
E1600 out1600 0 ref1600 fb1600 1e6
R3_1600 out1600 fb1600 99649.3668
R4_1600 fb1600 0 21820.3655
Rl1600 out1600 0 10
Vr1601 ref1601 0 0.589493838
E1601 out1601 0 ref1601 fb1601 1e6
R3_1601 out1601 fb1601 100353.557
R4_1601 fb1601 0 21966.2555
Rl1601 out1601 0 10
Vr1602 ref1602 0 0.608730521
E1602 out1602 0 ref1602 fb1602 1e6
R3_1602 out1602 fb1602 99786.0737
R4_1602 fb1602 0 22037.6578
Rl1602 out1602 0 10
Vr1603 ref1603 0 0.610649187
E1603 out1603 0 ref1603 fb1603 1e6
R3_1603 out1603 fb1603 99282.7651
R4_1603 fb1603 0 22197.8135
Rl1603 out1603 0 10
Vr1604 ref1604 0 0.591776927
E1604 out1604 0 ref1604 fb1604 1e6
R3_1604 out1604 fb1604 100016.449
R4_1604 fb1604 0 21855.5497
Rl1604 out1604 0 10
Vr1605 ref1605 0 0.593088178
E1605 out1605 0 ref1605 fb1605 1e6
R3_1605 out1605 fb1605 100429.684
R4_1605 fb1605 0 21903.7211
Rl1605 out1605 0 10
Vr1606 ref1606 0 0.595696926
E1606 out1606 0 ref1606 fb1606 1e6
R3_1606 out1606 fb1606 100024.514
R4_1606 fb1606 0 22217.5164
Rl1606 out1606 0 10
Vr1607 ref1607 0 0.611161693
E1607 out1607 0 ref1607 fb1607 1e6
R3_1607 out1607 fb1607 100131.658
R4_1607 fb1607 0 21992.2263
Rl1607 out1607 0 10
Vr1608 ref1608 0 0.589561631
E1608 out1608 0 ref1608 fb1608 1e6
R3_1608 out1608 fb1608 99591.6213
R4_1608 fb1608 0 21936.5721
Rl1608 out1608 0 10
Vr1609 ref1609 0 0.598901012
E1609 out1609 0 ref1609 fb1609 1e6
R3_1609 out1609 fb1609 99593.4932
R4_1609 fb1609 0 22031.0418
Rl1609 out1609 0 10
Vr1610 ref1610 0 0.605171531
E1610 out1610 0 ref1610 fb1610 1e6
R3_1610 out1610 fb1610 100215.098
R4_1610 fb1610 0 21784.3771
Rl1610 out1610 0 10
Vr1611 ref1611 0 0.611008873
E1611 out1611 0 ref1611 fb1611 1e6
R3_1611 out1611 fb1611 100098.545
R4_1611 fb1611 0 22038.9385
Rl1611 out1611 0 10
Vr1612 ref1612 0 0.610902684
E1612 out1612 0 ref1612 fb1612 1e6
R3_1612 out1612 fb1612 99402.6644
R4_1612 fb1612 0 21868.4458
Rl1612 out1612 0 10
Vr1613 ref1613 0 0.599609474
E1613 out1613 0 ref1613 fb1613 1e6
R3_1613 out1613 fb1613 100188.912
R4_1613 fb1613 0 21808.35
Rl1613 out1613 0 10
Vr1614 ref1614 0 0.606171629
E1614 out1614 0 ref1614 fb1614 1e6
R3_1614 out1614 fb1614 99543.2518
R4_1614 fb1614 0 22067.917
Rl1614 out1614 0 10
Vr1615 ref1615 0 0.589017449
E1615 out1615 0 ref1615 fb1615 1e6
R3_1615 out1615 fb1615 100489.357
R4_1615 fb1615 0 22010.3348
Rl1615 out1615 0 10
Vr1616 ref1616 0 0.593507337
E1616 out1616 0 ref1616 fb1616 1e6
R3_1616 out1616 fb1616 99665.4518
R4_1616 fb1616 0 21834.1038
Rl1616 out1616 0 10
Vr1617 ref1617 0 0.590532998
E1617 out1617 0 ref1617 fb1617 1e6
R3_1617 out1617 fb1617 99982.9817
R4_1617 fb1617 0 21880.8939
Rl1617 out1617 0 10
Vr1618 ref1618 0 0.604430522
E1618 out1618 0 ref1618 fb1618 1e6
R3_1618 out1618 fb1618 100813.266
R4_1618 fb1618 0 21846.0014
Rl1618 out1618 0 10
Vr1619 ref1619 0 0.600807689
E1619 out1619 0 ref1619 fb1619 1e6
R3_1619 out1619 fb1619 100071.891
R4_1619 fb1619 0 22016.3361
Rl1619 out1619 0 10
Vr1620 ref1620 0 0.597368989
E1620 out1620 0 ref1620 fb1620 1e6
R3_1620 out1620 fb1620 99882.3446
R4_1620 fb1620 0 22027.7945
Rl1620 out1620 0 10
Vr1621 ref1621 0 0.609802122
E1621 out1621 0 ref1621 fb1621 1e6
R3_1621 out1621 fb1621 100262.869
R4_1621 fb1621 0 22173.9551
Rl1621 out1621 0 10
Vr1622 ref1622 0 0.599605643
E1622 out1622 0 ref1622 fb1622 1e6
R3_1622 out1622 fb1622 100509.768
R4_1622 fb1622 0 22076.2792
Rl1622 out1622 0 10
Vr1623 ref1623 0 0.60559708
E1623 out1623 0 ref1623 fb1623 1e6
R3_1623 out1623 fb1623 99453.0439
R4_1623 fb1623 0 21982.05
Rl1623 out1623 0 10
Vr1624 ref1624 0 0.605331235
E1624 out1624 0 ref1624 fb1624 1e6
R3_1624 out1624 fb1624 100800.12
R4_1624 fb1624 0 22170.8392
Rl1624 out1624 0 10
Vr1625 ref1625 0 0.604402716
E1625 out1625 0 ref1625 fb1625 1e6
R3_1625 out1625 fb1625 99706.6626
R4_1625 fb1625 0 21888.8381
Rl1625 out1625 0 10
Vr1626 ref1626 0 0.589161749
E1626 out1626 0 ref1626 fb1626 1e6
R3_1626 out1626 fb1626 100520.235
R4_1626 fb1626 0 22112.7177
Rl1626 out1626 0 10
Vr1627 ref1627 0 0.607609494
E1627 out1627 0 ref1627 fb1627 1e6
R3_1627 out1627 fb1627 99583.5424
R4_1627 fb1627 0 21807.2726
Rl1627 out1627 0 10
Vr1628 ref1628 0 0.604127637
E1628 out1628 0 ref1628 fb1628 1e6
R3_1628 out1628 fb1628 100591.261
R4_1628 fb1628 0 21802.7905
Rl1628 out1628 0 10
Vr1629 ref1629 0 0.61067253
E1629 out1629 0 ref1629 fb1629 1e6
R3_1629 out1629 fb1629 100846.148
R4_1629 fb1629 0 21910.2811
Rl1629 out1629 0 10
Vr1630 ref1630 0 0.610217386
E1630 out1630 0 ref1630 fb1630 1e6
R3_1630 out1630 fb1630 100576.555
R4_1630 fb1630 0 22021.5642
Rl1630 out1630 0 10
Vr1631 ref1631 0 0.595268921
E1631 out1631 0 ref1631 fb1631 1e6
R3_1631 out1631 fb1631 99246.7991
R4_1631 fb1631 0 22211.258
Rl1631 out1631 0 10
Vr1632 ref1632 0 0.595746338
E1632 out1632 0 ref1632 fb1632 1e6
R3_1632 out1632 fb1632 100069.459
R4_1632 fb1632 0 21925.5448
Rl1632 out1632 0 10
Vr1633 ref1633 0 0.599748122
E1633 out1633 0 ref1633 fb1633 1e6
R3_1633 out1633 fb1633 100966.685
R4_1633 fb1633 0 22127.6368
Rl1633 out1633 0 10
Vr1634 ref1634 0 0.604849041
E1634 out1634 0 ref1634 fb1634 1e6
R3_1634 out1634 fb1634 99710.8652
R4_1634 fb1634 0 21784.8629
Rl1634 out1634 0 10
Vr1635 ref1635 0 0.602969371
E1635 out1635 0 ref1635 fb1635 1e6
R3_1635 out1635 fb1635 99548.5371
R4_1635 fb1635 0 21888.0722
Rl1635 out1635 0 10
Vr1636 ref1636 0 0.592242402
E1636 out1636 0 ref1636 fb1636 1e6
R3_1636 out1636 fb1636 100284.087
R4_1636 fb1636 0 21786.0586
Rl1636 out1636 0 10
Vr1637 ref1637 0 0.604898253
E1637 out1637 0 ref1637 fb1637 1e6
R3_1637 out1637 fb1637 100809.441
R4_1637 fb1637 0 21817.4827
Rl1637 out1637 0 10
Vr1638 ref1638 0 0.603599518
E1638 out1638 0 ref1638 fb1638 1e6
R3_1638 out1638 fb1638 99988.9315
R4_1638 fb1638 0 21794.7004
Rl1638 out1638 0 10
Vr1639 ref1639 0 0.608688135
E1639 out1639 0 ref1639 fb1639 1e6
R3_1639 out1639 fb1639 100901.942
R4_1639 fb1639 0 21971.5665
Rl1639 out1639 0 10
Vr1640 ref1640 0 0.59829728
E1640 out1640 0 ref1640 fb1640 1e6
R3_1640 out1640 fb1640 99254.2046
R4_1640 fb1640 0 22144.8234
Rl1640 out1640 0 10
Vr1641 ref1641 0 0.59588073
E1641 out1641 0 ref1641 fb1641 1e6
R3_1641 out1641 fb1641 99654.7375
R4_1641 fb1641 0 22150.7872
Rl1641 out1641 0 10
Vr1642 ref1642 0 0.607097279
E1642 out1642 0 ref1642 fb1642 1e6
R3_1642 out1642 fb1642 99281.2999
R4_1642 fb1642 0 22183.6245
Rl1642 out1642 0 10
Vr1643 ref1643 0 0.594178546
E1643 out1643 0 ref1643 fb1643 1e6
R3_1643 out1643 fb1643 100663.079
R4_1643 fb1643 0 21887.5008
Rl1643 out1643 0 10
Vr1644 ref1644 0 0.604973226
E1644 out1644 0 ref1644 fb1644 1e6
R3_1644 out1644 fb1644 100183.82
R4_1644 fb1644 0 21928.0124
Rl1644 out1644 0 10
Vr1645 ref1645 0 0.601752554
E1645 out1645 0 ref1645 fb1645 1e6
R3_1645 out1645 fb1645 100976.929
R4_1645 fb1645 0 22019.0678
Rl1645 out1645 0 10
Vr1646 ref1646 0 0.59202437
E1646 out1646 0 ref1646 fb1646 1e6
R3_1646 out1646 fb1646 99376.4637
R4_1646 fb1646 0 21805.8944
Rl1646 out1646 0 10
Vr1647 ref1647 0 0.598660911
E1647 out1647 0 ref1647 fb1647 1e6
R3_1647 out1647 fb1647 99940.6868
R4_1647 fb1647 0 22196.4497
Rl1647 out1647 0 10
Vr1648 ref1648 0 0.611138334
E1648 out1648 0 ref1648 fb1648 1e6
R3_1648 out1648 fb1648 99507.3162
R4_1648 fb1648 0 21813.3511
Rl1648 out1648 0 10
Vr1649 ref1649 0 0.604652407
E1649 out1649 0 ref1649 fb1649 1e6
R3_1649 out1649 fb1649 100496.323
R4_1649 fb1649 0 21974.743
Rl1649 out1649 0 10
Vr1650 ref1650 0 0.597366958
E1650 out1650 0 ref1650 fb1650 1e6
R3_1650 out1650 fb1650 99787.9141
R4_1650 fb1650 0 22212.1882
Rl1650 out1650 0 10
Vr1651 ref1651 0 0.60104914
E1651 out1651 0 ref1651 fb1651 1e6
R3_1651 out1651 fb1651 100031.285
R4_1651 fb1651 0 21905.2645
Rl1651 out1651 0 10
Vr1652 ref1652 0 0.594635991
E1652 out1652 0 ref1652 fb1652 1e6
R3_1652 out1652 fb1652 99381.8846
R4_1652 fb1652 0 21983.048
Rl1652 out1652 0 10
Vr1653 ref1653 0 0.606923046
E1653 out1653 0 ref1653 fb1653 1e6
R3_1653 out1653 fb1653 99531.9019
R4_1653 fb1653 0 22061.6897
Rl1653 out1653 0 10
Vr1654 ref1654 0 0.594748545
E1654 out1654 0 ref1654 fb1654 1e6
R3_1654 out1654 fb1654 100344.194
R4_1654 fb1654 0 21911.5038
Rl1654 out1654 0 10
Vr1655 ref1655 0 0.594688751
E1655 out1655 0 ref1655 fb1655 1e6
R3_1655 out1655 fb1655 100261.972
R4_1655 fb1655 0 22033.0215
Rl1655 out1655 0 10
Vr1656 ref1656 0 0.595981611
E1656 out1656 0 ref1656 fb1656 1e6
R3_1656 out1656 fb1656 100108.954
R4_1656 fb1656 0 21988.9379
Rl1656 out1656 0 10
Vr1657 ref1657 0 0.596018731
E1657 out1657 0 ref1657 fb1657 1e6
R3_1657 out1657 fb1657 99983.4954
R4_1657 fb1657 0 22020.6959
Rl1657 out1657 0 10
Vr1658 ref1658 0 0.601795015
E1658 out1658 0 ref1658 fb1658 1e6
R3_1658 out1658 fb1658 99635.3821
R4_1658 fb1658 0 22042.2407
Rl1658 out1658 0 10
Vr1659 ref1659 0 0.601674005
E1659 out1659 0 ref1659 fb1659 1e6
R3_1659 out1659 fb1659 100458.977
R4_1659 fb1659 0 22082.5331
Rl1659 out1659 0 10
Vr1660 ref1660 0 0.596659688
E1660 out1660 0 ref1660 fb1660 1e6
R3_1660 out1660 fb1660 100958.66
R4_1660 fb1660 0 22183.9144
Rl1660 out1660 0 10
Vr1661 ref1661 0 0.589703333
E1661 out1661 0 ref1661 fb1661 1e6
R3_1661 out1661 fb1661 100373.992
R4_1661 fb1661 0 22097.8985
Rl1661 out1661 0 10
Vr1662 ref1662 0 0.600649423
E1662 out1662 0 ref1662 fb1662 1e6
R3_1662 out1662 fb1662 99301.1136
R4_1662 fb1662 0 21946.854
Rl1662 out1662 0 10
Vr1663 ref1663 0 0.603626452
E1663 out1663 0 ref1663 fb1663 1e6
R3_1663 out1663 fb1663 100133.528
R4_1663 fb1663 0 21818.2251
Rl1663 out1663 0 10
Vr1664 ref1664 0 0.603551861
E1664 out1664 0 ref1664 fb1664 1e6
R3_1664 out1664 fb1664 99859.7762
R4_1664 fb1664 0 21984.3602
Rl1664 out1664 0 10
Vr1665 ref1665 0 0.609302393
E1665 out1665 0 ref1665 fb1665 1e6
R3_1665 out1665 fb1665 99628.2571
R4_1665 fb1665 0 21908.1363
Rl1665 out1665 0 10
Vr1666 ref1666 0 0.611632626
E1666 out1666 0 ref1666 fb1666 1e6
R3_1666 out1666 fb1666 99784.2074
R4_1666 fb1666 0 21872.4271
Rl1666 out1666 0 10
Vr1667 ref1667 0 0.603410518
E1667 out1667 0 ref1667 fb1667 1e6
R3_1667 out1667 fb1667 100986.434
R4_1667 fb1667 0 21997.3063
Rl1667 out1667 0 10
Vr1668 ref1668 0 0.603297673
E1668 out1668 0 ref1668 fb1668 1e6
R3_1668 out1668 fb1668 99004.8421
R4_1668 fb1668 0 22130.5635
Rl1668 out1668 0 10
Vr1669 ref1669 0 0.603812925
E1669 out1669 0 ref1669 fb1669 1e6
R3_1669 out1669 fb1669 100034.218
R4_1669 fb1669 0 21947.2734
Rl1669 out1669 0 10
Vr1670 ref1670 0 0.603563639
E1670 out1670 0 ref1670 fb1670 1e6
R3_1670 out1670 fb1670 100739.724
R4_1670 fb1670 0 22176.6138
Rl1670 out1670 0 10
Vr1671 ref1671 0 0.605373061
E1671 out1671 0 ref1671 fb1671 1e6
R3_1671 out1671 fb1671 100317.823
R4_1671 fb1671 0 22191.2943
Rl1671 out1671 0 10
Vr1672 ref1672 0 0.59094161
E1672 out1672 0 ref1672 fb1672 1e6
R3_1672 out1672 fb1672 100249.16
R4_1672 fb1672 0 22164.9845
Rl1672 out1672 0 10
Vr1673 ref1673 0 0.595223682
E1673 out1673 0 ref1673 fb1673 1e6
R3_1673 out1673 fb1673 99231.5561
R4_1673 fb1673 0 21941.629
Rl1673 out1673 0 10
Vr1674 ref1674 0 0.610674576
E1674 out1674 0 ref1674 fb1674 1e6
R3_1674 out1674 fb1674 99051.9987
R4_1674 fb1674 0 22033.8063
Rl1674 out1674 0 10
Vr1675 ref1675 0 0.606231916
E1675 out1675 0 ref1675 fb1675 1e6
R3_1675 out1675 fb1675 99447.7782
R4_1675 fb1675 0 21945.8071
Rl1675 out1675 0 10
Vr1676 ref1676 0 0.59906307
E1676 out1676 0 ref1676 fb1676 1e6
R3_1676 out1676 fb1676 99351.2107
R4_1676 fb1676 0 22188.8179
Rl1676 out1676 0 10
Vr1677 ref1677 0 0.596217316
E1677 out1677 0 ref1677 fb1677 1e6
R3_1677 out1677 fb1677 99670.0784
R4_1677 fb1677 0 22091.5149
Rl1677 out1677 0 10
Vr1678 ref1678 0 0.611496589
E1678 out1678 0 ref1678 fb1678 1e6
R3_1678 out1678 fb1678 99206.1733
R4_1678 fb1678 0 21837.7778
Rl1678 out1678 0 10
Vr1679 ref1679 0 0.606503304
E1679 out1679 0 ref1679 fb1679 1e6
R3_1679 out1679 fb1679 100640.347
R4_1679 fb1679 0 22035.7845
Rl1679 out1679 0 10
Vr1680 ref1680 0 0.600490539
E1680 out1680 0 ref1680 fb1680 1e6
R3_1680 out1680 fb1680 100288.317
R4_1680 fb1680 0 22122.2685
Rl1680 out1680 0 10
Vr1681 ref1681 0 0.593418891
E1681 out1681 0 ref1681 fb1681 1e6
R3_1681 out1681 fb1681 100244.545
R4_1681 fb1681 0 21847.7951
Rl1681 out1681 0 10
Vr1682 ref1682 0 0.589352903
E1682 out1682 0 ref1682 fb1682 1e6
R3_1682 out1682 fb1682 100498.682
R4_1682 fb1682 0 21939.0284
Rl1682 out1682 0 10
Vr1683 ref1683 0 0.604348583
E1683 out1683 0 ref1683 fb1683 1e6
R3_1683 out1683 fb1683 99431.3364
R4_1683 fb1683 0 22068.5053
Rl1683 out1683 0 10
Vr1684 ref1684 0 0.600472693
E1684 out1684 0 ref1684 fb1684 1e6
R3_1684 out1684 fb1684 100797.022
R4_1684 fb1684 0 21919.2645
Rl1684 out1684 0 10
Vr1685 ref1685 0 0.607698722
E1685 out1685 0 ref1685 fb1685 1e6
R3_1685 out1685 fb1685 99556.2292
R4_1685 fb1685 0 21872.3352
Rl1685 out1685 0 10
Vr1686 ref1686 0 0.608221345
E1686 out1686 0 ref1686 fb1686 1e6
R3_1686 out1686 fb1686 100823.506
R4_1686 fb1686 0 21867.3533
Rl1686 out1686 0 10
Vr1687 ref1687 0 0.606240865
E1687 out1687 0 ref1687 fb1687 1e6
R3_1687 out1687 fb1687 100141.398
R4_1687 fb1687 0 21925.3053
Rl1687 out1687 0 10
Vr1688 ref1688 0 0.591891662
E1688 out1688 0 ref1688 fb1688 1e6
R3_1688 out1688 fb1688 99511.9439
R4_1688 fb1688 0 21899.0218
Rl1688 out1688 0 10
Vr1689 ref1689 0 0.589404
E1689 out1689 0 ref1689 fb1689 1e6
R3_1689 out1689 fb1689 100480.258
R4_1689 fb1689 0 22115.383
Rl1689 out1689 0 10
Vr1690 ref1690 0 0.602242888
E1690 out1690 0 ref1690 fb1690 1e6
R3_1690 out1690 fb1690 100026.124
R4_1690 fb1690 0 21845.0491
Rl1690 out1690 0 10
Vr1691 ref1691 0 0.592393951
E1691 out1691 0 ref1691 fb1691 1e6
R3_1691 out1691 fb1691 99076.992
R4_1691 fb1691 0 22138.1331
Rl1691 out1691 0 10
Vr1692 ref1692 0 0.600689964
E1692 out1692 0 ref1692 fb1692 1e6
R3_1692 out1692 fb1692 100105.834
R4_1692 fb1692 0 22031.1607
Rl1692 out1692 0 10
Vr1693 ref1693 0 0.595311378
E1693 out1693 0 ref1693 fb1693 1e6
R3_1693 out1693 fb1693 100307.014
R4_1693 fb1693 0 22128.57
Rl1693 out1693 0 10
Vr1694 ref1694 0 0.604355153
E1694 out1694 0 ref1694 fb1694 1e6
R3_1694 out1694 fb1694 100060.512
R4_1694 fb1694 0 21892.3038
Rl1694 out1694 0 10
Vr1695 ref1695 0 0.599638002
E1695 out1695 0 ref1695 fb1695 1e6
R3_1695 out1695 fb1695 99178.8789
R4_1695 fb1695 0 21933.8137
Rl1695 out1695 0 10
Vr1696 ref1696 0 0.604242925
E1696 out1696 0 ref1696 fb1696 1e6
R3_1696 out1696 fb1696 100997.907
R4_1696 fb1696 0 22200.853
Rl1696 out1696 0 10
Vr1697 ref1697 0 0.611046057
E1697 out1697 0 ref1697 fb1697 1e6
R3_1697 out1697 fb1697 99263.5303
R4_1697 fb1697 0 21802.4914
Rl1697 out1697 0 10
Vr1698 ref1698 0 0.601433498
E1698 out1698 0 ref1698 fb1698 1e6
R3_1698 out1698 fb1698 100596.778
R4_1698 fb1698 0 21998.9216
Rl1698 out1698 0 10
Vr1699 ref1699 0 0.608344091
E1699 out1699 0 ref1699 fb1699 1e6
R3_1699 out1699 fb1699 100861.058
R4_1699 fb1699 0 21786.5675
Rl1699 out1699 0 10
Vr1700 ref1700 0 0.601312655
E1700 out1700 0 ref1700 fb1700 1e6
R3_1700 out1700 fb1700 99170.3813
R4_1700 fb1700 0 22141.5102
Rl1700 out1700 0 10
Vr1701 ref1701 0 0.601915037
E1701 out1701 0 ref1701 fb1701 1e6
R3_1701 out1701 fb1701 100531.909
R4_1701 fb1701 0 21977.4826
Rl1701 out1701 0 10
Vr1702 ref1702 0 0.598035413
E1702 out1702 0 ref1702 fb1702 1e6
R3_1702 out1702 fb1702 100590.972
R4_1702 fb1702 0 22088.7298
Rl1702 out1702 0 10
Vr1703 ref1703 0 0.597073702
E1703 out1703 0 ref1703 fb1703 1e6
R3_1703 out1703 fb1703 99091.8032
R4_1703 fb1703 0 21908.2066
Rl1703 out1703 0 10
Vr1704 ref1704 0 0.598605268
E1704 out1704 0 ref1704 fb1704 1e6
R3_1704 out1704 fb1704 100968.321
R4_1704 fb1704 0 21896.495
Rl1704 out1704 0 10
Vr1705 ref1705 0 0.603035222
E1705 out1705 0 ref1705 fb1705 1e6
R3_1705 out1705 fb1705 99759.5476
R4_1705 fb1705 0 22039.7948
Rl1705 out1705 0 10
Vr1706 ref1706 0 0.609679222
E1706 out1706 0 ref1706 fb1706 1e6
R3_1706 out1706 fb1706 100057.872
R4_1706 fb1706 0 21964.1459
Rl1706 out1706 0 10
Vr1707 ref1707 0 0.588644743
E1707 out1707 0 ref1707 fb1707 1e6
R3_1707 out1707 fb1707 100806.641
R4_1707 fb1707 0 21790.9492
Rl1707 out1707 0 10
Vr1708 ref1708 0 0.588524246
E1708 out1708 0 ref1708 fb1708 1e6
R3_1708 out1708 fb1708 99794.4192
R4_1708 fb1708 0 21781.0763
Rl1708 out1708 0 10
Vr1709 ref1709 0 0.600136866
E1709 out1709 0 ref1709 fb1709 1e6
R3_1709 out1709 fb1709 99913.1556
R4_1709 fb1709 0 21832.6417
Rl1709 out1709 0 10
Vr1710 ref1710 0 0.605909769
E1710 out1710 0 ref1710 fb1710 1e6
R3_1710 out1710 fb1710 99689.9497
R4_1710 fb1710 0 22017.3033
Rl1710 out1710 0 10
Vr1711 ref1711 0 0.603833637
E1711 out1711 0 ref1711 fb1711 1e6
R3_1711 out1711 fb1711 100255.253
R4_1711 fb1711 0 21883.7465
Rl1711 out1711 0 10
Vr1712 ref1712 0 0.588228306
E1712 out1712 0 ref1712 fb1712 1e6
R3_1712 out1712 fb1712 100271.859
R4_1712 fb1712 0 22213.7895
Rl1712 out1712 0 10
Vr1713 ref1713 0 0.608518111
E1713 out1713 0 ref1713 fb1713 1e6
R3_1713 out1713 fb1713 99741.0288
R4_1713 fb1713 0 21919.5296
Rl1713 out1713 0 10
Vr1714 ref1714 0 0.589708969
E1714 out1714 0 ref1714 fb1714 1e6
R3_1714 out1714 fb1714 99949.5681
R4_1714 fb1714 0 22022.5604
Rl1714 out1714 0 10
Vr1715 ref1715 0 0.602095658
E1715 out1715 0 ref1715 fb1715 1e6
R3_1715 out1715 fb1715 99976.0144
R4_1715 fb1715 0 22169.3962
Rl1715 out1715 0 10
Vr1716 ref1716 0 0.611486922
E1716 out1716 0 ref1716 fb1716 1e6
R3_1716 out1716 fb1716 100817.273
R4_1716 fb1716 0 21806.1466
Rl1716 out1716 0 10
Vr1717 ref1717 0 0.592632748
E1717 out1717 0 ref1717 fb1717 1e6
R3_1717 out1717 fb1717 99003.246
R4_1717 fb1717 0 22129.5057
Rl1717 out1717 0 10
Vr1718 ref1718 0 0.601584583
E1718 out1718 0 ref1718 fb1718 1e6
R3_1718 out1718 fb1718 99867.2495
R4_1718 fb1718 0 21865.6915
Rl1718 out1718 0 10
Vr1719 ref1719 0 0.610750416
E1719 out1719 0 ref1719 fb1719 1e6
R3_1719 out1719 fb1719 100385.391
R4_1719 fb1719 0 22124.5229
Rl1719 out1719 0 10
Vr1720 ref1720 0 0.61144753
E1720 out1720 0 ref1720 fb1720 1e6
R3_1720 out1720 fb1720 99642.8369
R4_1720 fb1720 0 22028.9152
Rl1720 out1720 0 10
Vr1721 ref1721 0 0.594389558
E1721 out1721 0 ref1721 fb1721 1e6
R3_1721 out1721 fb1721 100100.743
R4_1721 fb1721 0 21844.0311
Rl1721 out1721 0 10
Vr1722 ref1722 0 0.599662319
E1722 out1722 0 ref1722 fb1722 1e6
R3_1722 out1722 fb1722 100996.322
R4_1722 fb1722 0 21875.9531
Rl1722 out1722 0 10
Vr1723 ref1723 0 0.591136378
E1723 out1723 0 ref1723 fb1723 1e6
R3_1723 out1723 fb1723 99803.4824
R4_1723 fb1723 0 22000.3336
Rl1723 out1723 0 10
Vr1724 ref1724 0 0.595375212
E1724 out1724 0 ref1724 fb1724 1e6
R3_1724 out1724 fb1724 100357.211
R4_1724 fb1724 0 21790.2784
Rl1724 out1724 0 10
Vr1725 ref1725 0 0.58852827
E1725 out1725 0 ref1725 fb1725 1e6
R3_1725 out1725 fb1725 100531.44
R4_1725 fb1725 0 22106.0628
Rl1725 out1725 0 10
Vr1726 ref1726 0 0.590091482
E1726 out1726 0 ref1726 fb1726 1e6
R3_1726 out1726 fb1726 99901.477
R4_1726 fb1726 0 21799.725
Rl1726 out1726 0 10
Vr1727 ref1727 0 0.611969915
E1727 out1727 0 ref1727 fb1727 1e6
R3_1727 out1727 fb1727 99006.6336
R4_1727 fb1727 0 21960.3308
Rl1727 out1727 0 10
Vr1728 ref1728 0 0.595602964
E1728 out1728 0 ref1728 fb1728 1e6
R3_1728 out1728 fb1728 100351.523
R4_1728 fb1728 0 21833.2274
Rl1728 out1728 0 10
Vr1729 ref1729 0 0.588742473
E1729 out1729 0 ref1729 fb1729 1e6
R3_1729 out1729 fb1729 99481.743
R4_1729 fb1729 0 22130.7521
Rl1729 out1729 0 10
Vr1730 ref1730 0 0.610168987
E1730 out1730 0 ref1730 fb1730 1e6
R3_1730 out1730 fb1730 100919.9
R4_1730 fb1730 0 21928.2476
Rl1730 out1730 0 10
Vr1731 ref1731 0 0.6081113
E1731 out1731 0 ref1731 fb1731 1e6
R3_1731 out1731 fb1731 100152.256
R4_1731 fb1731 0 22116.21
Rl1731 out1731 0 10
Vr1732 ref1732 0 0.605974502
E1732 out1732 0 ref1732 fb1732 1e6
R3_1732 out1732 fb1732 100374.581
R4_1732 fb1732 0 21998.5133
Rl1732 out1732 0 10
Vr1733 ref1733 0 0.610607667
E1733 out1733 0 ref1733 fb1733 1e6
R3_1733 out1733 fb1733 100046.958
R4_1733 fb1733 0 22001.7756
Rl1733 out1733 0 10
Vr1734 ref1734 0 0.610295597
E1734 out1734 0 ref1734 fb1734 1e6
R3_1734 out1734 fb1734 99694.1539
R4_1734 fb1734 0 22139.6271
Rl1734 out1734 0 10
Vr1735 ref1735 0 0.605854267
E1735 out1735 0 ref1735 fb1735 1e6
R3_1735 out1735 fb1735 99214.1197
R4_1735 fb1735 0 22120.0691
Rl1735 out1735 0 10
Vr1736 ref1736 0 0.604305033
E1736 out1736 0 ref1736 fb1736 1e6
R3_1736 out1736 fb1736 100827.681
R4_1736 fb1736 0 22026.6013
Rl1736 out1736 0 10
Vr1737 ref1737 0 0.603222248
E1737 out1737 0 ref1737 fb1737 1e6
R3_1737 out1737 fb1737 99288.9997
R4_1737 fb1737 0 22057.5508
Rl1737 out1737 0 10
Vr1738 ref1738 0 0.589741415
E1738 out1738 0 ref1738 fb1738 1e6
R3_1738 out1738 fb1738 100933.658
R4_1738 fb1738 0 21928.2512
Rl1738 out1738 0 10
Vr1739 ref1739 0 0.590919566
E1739 out1739 0 ref1739 fb1739 1e6
R3_1739 out1739 fb1739 100764.619
R4_1739 fb1739 0 22184.5237
Rl1739 out1739 0 10
Vr1740 ref1740 0 0.601194816
E1740 out1740 0 ref1740 fb1740 1e6
R3_1740 out1740 fb1740 99287.5161
R4_1740 fb1740 0 21941.3774
Rl1740 out1740 0 10
Vr1741 ref1741 0 0.604433779
E1741 out1741 0 ref1741 fb1741 1e6
R3_1741 out1741 fb1741 100632.867
R4_1741 fb1741 0 22080.2281
Rl1741 out1741 0 10
Vr1742 ref1742 0 0.592333607
E1742 out1742 0 ref1742 fb1742 1e6
R3_1742 out1742 fb1742 100547.344
R4_1742 fb1742 0 21853.9977
Rl1742 out1742 0 10
Vr1743 ref1743 0 0.600785119
E1743 out1743 0 ref1743 fb1743 1e6
R3_1743 out1743 fb1743 100542.796
R4_1743 fb1743 0 22164.9117
Rl1743 out1743 0 10
Vr1744 ref1744 0 0.595661188
E1744 out1744 0 ref1744 fb1744 1e6
R3_1744 out1744 fb1744 99762.2586
R4_1744 fb1744 0 21914.473
Rl1744 out1744 0 10
Vr1745 ref1745 0 0.609239667
E1745 out1745 0 ref1745 fb1745 1e6
R3_1745 out1745 fb1745 100485.363
R4_1745 fb1745 0 21784.3616
Rl1745 out1745 0 10
Vr1746 ref1746 0 0.591816571
E1746 out1746 0 ref1746 fb1746 1e6
R3_1746 out1746 fb1746 99062.1591
R4_1746 fb1746 0 21949.7939
Rl1746 out1746 0 10
Vr1747 ref1747 0 0.592413462
E1747 out1747 0 ref1747 fb1747 1e6
R3_1747 out1747 fb1747 100121.768
R4_1747 fb1747 0 22072.8224
Rl1747 out1747 0 10
Vr1748 ref1748 0 0.59476391
E1748 out1748 0 ref1748 fb1748 1e6
R3_1748 out1748 fb1748 100882.932
R4_1748 fb1748 0 21900.5205
Rl1748 out1748 0 10
Vr1749 ref1749 0 0.594962054
E1749 out1749 0 ref1749 fb1749 1e6
R3_1749 out1749 fb1749 99606.6346
R4_1749 fb1749 0 22121.0404
Rl1749 out1749 0 10
Vr1750 ref1750 0 0.592765589
E1750 out1750 0 ref1750 fb1750 1e6
R3_1750 out1750 fb1750 99026.3327
R4_1750 fb1750 0 21955.4598
Rl1750 out1750 0 10
Vr1751 ref1751 0 0.59039894
E1751 out1751 0 ref1751 fb1751 1e6
R3_1751 out1751 fb1751 100255.358
R4_1751 fb1751 0 22152.9206
Rl1751 out1751 0 10
Vr1752 ref1752 0 0.607836247
E1752 out1752 0 ref1752 fb1752 1e6
R3_1752 out1752 fb1752 99189.1459
R4_1752 fb1752 0 21786.01
Rl1752 out1752 0 10
Vr1753 ref1753 0 0.610729839
E1753 out1753 0 ref1753 fb1753 1e6
R3_1753 out1753 fb1753 100193.207
R4_1753 fb1753 0 21899.5475
Rl1753 out1753 0 10
Vr1754 ref1754 0 0.609360905
E1754 out1754 0 ref1754 fb1754 1e6
R3_1754 out1754 fb1754 99960.2136
R4_1754 fb1754 0 22105.8436
Rl1754 out1754 0 10
Vr1755 ref1755 0 0.602812245
E1755 out1755 0 ref1755 fb1755 1e6
R3_1755 out1755 fb1755 99899.4481
R4_1755 fb1755 0 22129.7336
Rl1755 out1755 0 10
Vr1756 ref1756 0 0.60150053
E1756 out1756 0 ref1756 fb1756 1e6
R3_1756 out1756 fb1756 100976.963
R4_1756 fb1756 0 22169.6859
Rl1756 out1756 0 10
Vr1757 ref1757 0 0.596046095
E1757 out1757 0 ref1757 fb1757 1e6
R3_1757 out1757 fb1757 99831.7132
R4_1757 fb1757 0 21988.356
Rl1757 out1757 0 10
Vr1758 ref1758 0 0.60972394
E1758 out1758 0 ref1758 fb1758 1e6
R3_1758 out1758 fb1758 100007.817
R4_1758 fb1758 0 21875.0583
Rl1758 out1758 0 10
Vr1759 ref1759 0 0.609189556
E1759 out1759 0 ref1759 fb1759 1e6
R3_1759 out1759 fb1759 100480.315
R4_1759 fb1759 0 22061.176
Rl1759 out1759 0 10
Vr1760 ref1760 0 0.589559445
E1760 out1760 0 ref1760 fb1760 1e6
R3_1760 out1760 fb1760 100256.415
R4_1760 fb1760 0 22027.8446
Rl1760 out1760 0 10
Vr1761 ref1761 0 0.593740847
E1761 out1761 0 ref1761 fb1761 1e6
R3_1761 out1761 fb1761 99282.711
R4_1761 fb1761 0 22066.0738
Rl1761 out1761 0 10
Vr1762 ref1762 0 0.590326895
E1762 out1762 0 ref1762 fb1762 1e6
R3_1762 out1762 fb1762 99272.475
R4_1762 fb1762 0 22044.9021
Rl1762 out1762 0 10
Vr1763 ref1763 0 0.58890106
E1763 out1763 0 ref1763 fb1763 1e6
R3_1763 out1763 fb1763 100708.645
R4_1763 fb1763 0 21917.7513
Rl1763 out1763 0 10
Vr1764 ref1764 0 0.606869541
E1764 out1764 0 ref1764 fb1764 1e6
R3_1764 out1764 fb1764 99124.5176
R4_1764 fb1764 0 21924.2838
Rl1764 out1764 0 10
Vr1765 ref1765 0 0.600717687
E1765 out1765 0 ref1765 fb1765 1e6
R3_1765 out1765 fb1765 100564.119
R4_1765 fb1765 0 21997.3938
Rl1765 out1765 0 10
Vr1766 ref1766 0 0.589902552
E1766 out1766 0 ref1766 fb1766 1e6
R3_1766 out1766 fb1766 99459.5539
R4_1766 fb1766 0 22148.2832
Rl1766 out1766 0 10
Vr1767 ref1767 0 0.602167801
E1767 out1767 0 ref1767 fb1767 1e6
R3_1767 out1767 fb1767 99890.0432
R4_1767 fb1767 0 22080.3476
Rl1767 out1767 0 10
Vr1768 ref1768 0 0.604418745
E1768 out1768 0 ref1768 fb1768 1e6
R3_1768 out1768 fb1768 100779.455
R4_1768 fb1768 0 22124.5466
Rl1768 out1768 0 10
Vr1769 ref1769 0 0.609955158
E1769 out1769 0 ref1769 fb1769 1e6
R3_1769 out1769 fb1769 99431.3052
R4_1769 fb1769 0 22176.8777
Rl1769 out1769 0 10
Vr1770 ref1770 0 0.609464947
E1770 out1770 0 ref1770 fb1770 1e6
R3_1770 out1770 fb1770 100131.583
R4_1770 fb1770 0 22120.632
Rl1770 out1770 0 10
Vr1771 ref1771 0 0.606712033
E1771 out1771 0 ref1771 fb1771 1e6
R3_1771 out1771 fb1771 99490.1732
R4_1771 fb1771 0 22149.2181
Rl1771 out1771 0 10
Vr1772 ref1772 0 0.60732626
E1772 out1772 0 ref1772 fb1772 1e6
R3_1772 out1772 fb1772 100637.822
R4_1772 fb1772 0 22035.956
Rl1772 out1772 0 10
Vr1773 ref1773 0 0.597986441
E1773 out1773 0 ref1773 fb1773 1e6
R3_1773 out1773 fb1773 100782.666
R4_1773 fb1773 0 21913.7384
Rl1773 out1773 0 10
Vr1774 ref1774 0 0.610717612
E1774 out1774 0 ref1774 fb1774 1e6
R3_1774 out1774 fb1774 99300.1305
R4_1774 fb1774 0 22118.4337
Rl1774 out1774 0 10
Vr1775 ref1775 0 0.602216061
E1775 out1775 0 ref1775 fb1775 1e6
R3_1775 out1775 fb1775 99433.6742
R4_1775 fb1775 0 22184.0418
Rl1775 out1775 0 10
Vr1776 ref1776 0 0.592324409
E1776 out1776 0 ref1776 fb1776 1e6
R3_1776 out1776 fb1776 100188.033
R4_1776 fb1776 0 22153.6955
Rl1776 out1776 0 10
Vr1777 ref1777 0 0.606669019
E1777 out1777 0 ref1777 fb1777 1e6
R3_1777 out1777 fb1777 100745.825
R4_1777 fb1777 0 21998.5216
Rl1777 out1777 0 10
Vr1778 ref1778 0 0.591225682
E1778 out1778 0 ref1778 fb1778 1e6
R3_1778 out1778 fb1778 99492.6293
R4_1778 fb1778 0 21837.2273
Rl1778 out1778 0 10
Vr1779 ref1779 0 0.608954187
E1779 out1779 0 ref1779 fb1779 1e6
R3_1779 out1779 fb1779 99903.972
R4_1779 fb1779 0 21810.4963
Rl1779 out1779 0 10
Vr1780 ref1780 0 0.593601282
E1780 out1780 0 ref1780 fb1780 1e6
R3_1780 out1780 fb1780 99281.148
R4_1780 fb1780 0 21983.5237
Rl1780 out1780 0 10
Vr1781 ref1781 0 0.590210877
E1781 out1781 0 ref1781 fb1781 1e6
R3_1781 out1781 fb1781 99163.7853
R4_1781 fb1781 0 22127.98
Rl1781 out1781 0 10
Vr1782 ref1782 0 0.590934657
E1782 out1782 0 ref1782 fb1782 1e6
R3_1782 out1782 fb1782 99907.3847
R4_1782 fb1782 0 22104.1914
Rl1782 out1782 0 10
Vr1783 ref1783 0 0.609698579
E1783 out1783 0 ref1783 fb1783 1e6
R3_1783 out1783 fb1783 99515.278
R4_1783 fb1783 0 22139.1464
Rl1783 out1783 0 10
Vr1784 ref1784 0 0.589930023
E1784 out1784 0 ref1784 fb1784 1e6
R3_1784 out1784 fb1784 99777.6098
R4_1784 fb1784 0 21885.7611
Rl1784 out1784 0 10
Vr1785 ref1785 0 0.605568561
E1785 out1785 0 ref1785 fb1785 1e6
R3_1785 out1785 fb1785 100334.195
R4_1785 fb1785 0 21895.6948
Rl1785 out1785 0 10
Vr1786 ref1786 0 0.588027599
E1786 out1786 0 ref1786 fb1786 1e6
R3_1786 out1786 fb1786 99773.0292
R4_1786 fb1786 0 21806.6232
Rl1786 out1786 0 10
Vr1787 ref1787 0 0.604588453
E1787 out1787 0 ref1787 fb1787 1e6
R3_1787 out1787 fb1787 100337.517
R4_1787 fb1787 0 21803.7227
Rl1787 out1787 0 10
Vr1788 ref1788 0 0.590878664
E1788 out1788 0 ref1788 fb1788 1e6
R3_1788 out1788 fb1788 100300.706
R4_1788 fb1788 0 21974.4276
Rl1788 out1788 0 10
Vr1789 ref1789 0 0.593501231
E1789 out1789 0 ref1789 fb1789 1e6
R3_1789 out1789 fb1789 99970.7007
R4_1789 fb1789 0 21920.4135
Rl1789 out1789 0 10
Vr1790 ref1790 0 0.592383698
E1790 out1790 0 ref1790 fb1790 1e6
R3_1790 out1790 fb1790 99225.1392
R4_1790 fb1790 0 21915.4659
Rl1790 out1790 0 10
Vr1791 ref1791 0 0.60284381
E1791 out1791 0 ref1791 fb1791 1e6
R3_1791 out1791 fb1791 100547.641
R4_1791 fb1791 0 22212.3259
Rl1791 out1791 0 10
Vr1792 ref1792 0 0.607528051
E1792 out1792 0 ref1792 fb1792 1e6
R3_1792 out1792 fb1792 99016.3632
R4_1792 fb1792 0 22051.6685
Rl1792 out1792 0 10
Vr1793 ref1793 0 0.593581773
E1793 out1793 0 ref1793 fb1793 1e6
R3_1793 out1793 fb1793 100569.527
R4_1793 fb1793 0 22134.1944
Rl1793 out1793 0 10
Vr1794 ref1794 0 0.592629897
E1794 out1794 0 ref1794 fb1794 1e6
R3_1794 out1794 fb1794 100689.101
R4_1794 fb1794 0 21827.008
Rl1794 out1794 0 10
Vr1795 ref1795 0 0.600555986
E1795 out1795 0 ref1795 fb1795 1e6
R3_1795 out1795 fb1795 99778.8124
R4_1795 fb1795 0 22098.7507
Rl1795 out1795 0 10
Vr1796 ref1796 0 0.610223379
E1796 out1796 0 ref1796 fb1796 1e6
R3_1796 out1796 fb1796 99724.5589
R4_1796 fb1796 0 22020.4713
Rl1796 out1796 0 10
Vr1797 ref1797 0 0.58925281
E1797 out1797 0 ref1797 fb1797 1e6
R3_1797 out1797 fb1797 100645.593
R4_1797 fb1797 0 21870.3059
Rl1797 out1797 0 10
Vr1798 ref1798 0 0.605724741
E1798 out1798 0 ref1798 fb1798 1e6
R3_1798 out1798 fb1798 99898.3823
R4_1798 fb1798 0 21953.6272
Rl1798 out1798 0 10
Vr1799 ref1799 0 0.601305896
E1799 out1799 0 ref1799 fb1799 1e6
R3_1799 out1799 fb1799 99863.129
R4_1799 fb1799 0 21944.5999
Rl1799 out1799 0 10
Vr1800 ref1800 0 0.588644395
E1800 out1800 0 ref1800 fb1800 1e6
R3_1800 out1800 fb1800 100310.346
R4_1800 fb1800 0 21867.3663
Rl1800 out1800 0 10
Vr1801 ref1801 0 0.605732114
E1801 out1801 0 ref1801 fb1801 1e6
R3_1801 out1801 fb1801 100518.459
R4_1801 fb1801 0 21804.4379
Rl1801 out1801 0 10
Vr1802 ref1802 0 0.589520042
E1802 out1802 0 ref1802 fb1802 1e6
R3_1802 out1802 fb1802 100184.66
R4_1802 fb1802 0 21789.5122
Rl1802 out1802 0 10
Vr1803 ref1803 0 0.590958
E1803 out1803 0 ref1803 fb1803 1e6
R3_1803 out1803 fb1803 100476.113
R4_1803 fb1803 0 21949.2845
Rl1803 out1803 0 10
Vr1804 ref1804 0 0.607415952
E1804 out1804 0 ref1804 fb1804 1e6
R3_1804 out1804 fb1804 99144.2985
R4_1804 fb1804 0 22201.6042
Rl1804 out1804 0 10
Vr1805 ref1805 0 0.595297044
E1805 out1805 0 ref1805 fb1805 1e6
R3_1805 out1805 fb1805 99578.3533
R4_1805 fb1805 0 21814.0532
Rl1805 out1805 0 10
Vr1806 ref1806 0 0.608452471
E1806 out1806 0 ref1806 fb1806 1e6
R3_1806 out1806 fb1806 99995.4642
R4_1806 fb1806 0 22049.5352
Rl1806 out1806 0 10
Vr1807 ref1807 0 0.59415681
E1807 out1807 0 ref1807 fb1807 1e6
R3_1807 out1807 fb1807 99499.7132
R4_1807 fb1807 0 22209.1364
Rl1807 out1807 0 10
Vr1808 ref1808 0 0.593414718
E1808 out1808 0 ref1808 fb1808 1e6
R3_1808 out1808 fb1808 99786.8385
R4_1808 fb1808 0 22214.8858
Rl1808 out1808 0 10
Vr1809 ref1809 0 0.60972253
E1809 out1809 0 ref1809 fb1809 1e6
R3_1809 out1809 fb1809 99152.3274
R4_1809 fb1809 0 22163.9208
Rl1809 out1809 0 10
Vr1810 ref1810 0 0.58840106
E1810 out1810 0 ref1810 fb1810 1e6
R3_1810 out1810 fb1810 100497.373
R4_1810 fb1810 0 22044.6311
Rl1810 out1810 0 10
Vr1811 ref1811 0 0.592182137
E1811 out1811 0 ref1811 fb1811 1e6
R3_1811 out1811 fb1811 100272.74
R4_1811 fb1811 0 21936.0787
Rl1811 out1811 0 10
Vr1812 ref1812 0 0.592379978
E1812 out1812 0 ref1812 fb1812 1e6
R3_1812 out1812 fb1812 99524.296
R4_1812 fb1812 0 21809.4992
Rl1812 out1812 0 10
Vr1813 ref1813 0 0.608740828
E1813 out1813 0 ref1813 fb1813 1e6
R3_1813 out1813 fb1813 100836.329
R4_1813 fb1813 0 21832.1572
Rl1813 out1813 0 10
Vr1814 ref1814 0 0.611802525
E1814 out1814 0 ref1814 fb1814 1e6
R3_1814 out1814 fb1814 99751.7247
R4_1814 fb1814 0 22014.6594
Rl1814 out1814 0 10
Vr1815 ref1815 0 0.594576614
E1815 out1815 0 ref1815 fb1815 1e6
R3_1815 out1815 fb1815 99447.5557
R4_1815 fb1815 0 22041.3713
Rl1815 out1815 0 10
Vr1816 ref1816 0 0.59963273
E1816 out1816 0 ref1816 fb1816 1e6
R3_1816 out1816 fb1816 99412.7739
R4_1816 fb1816 0 22217.5655
Rl1816 out1816 0 10
Vr1817 ref1817 0 0.59609787
E1817 out1817 0 ref1817 fb1817 1e6
R3_1817 out1817 fb1817 99117.5087
R4_1817 fb1817 0 22070.1926
Rl1817 out1817 0 10
Vr1818 ref1818 0 0.604091713
E1818 out1818 0 ref1818 fb1818 1e6
R3_1818 out1818 fb1818 99435.4827
R4_1818 fb1818 0 22075.6716
Rl1818 out1818 0 10
Vr1819 ref1819 0 0.590785887
E1819 out1819 0 ref1819 fb1819 1e6
R3_1819 out1819 fb1819 100361.935
R4_1819 fb1819 0 21880.6503
Rl1819 out1819 0 10
Vr1820 ref1820 0 0.601324812
E1820 out1820 0 ref1820 fb1820 1e6
R3_1820 out1820 fb1820 100046.705
R4_1820 fb1820 0 22162.4032
Rl1820 out1820 0 10
Vr1821 ref1821 0 0.593920746
E1821 out1821 0 ref1821 fb1821 1e6
R3_1821 out1821 fb1821 100558.074
R4_1821 fb1821 0 21978.6429
Rl1821 out1821 0 10
Vr1822 ref1822 0 0.608850222
E1822 out1822 0 ref1822 fb1822 1e6
R3_1822 out1822 fb1822 100924.462
R4_1822 fb1822 0 22154.216
Rl1822 out1822 0 10
Vr1823 ref1823 0 0.599890584
E1823 out1823 0 ref1823 fb1823 1e6
R3_1823 out1823 fb1823 99387.1047
R4_1823 fb1823 0 22063.0386
Rl1823 out1823 0 10
Vr1824 ref1824 0 0.596788656
E1824 out1824 0 ref1824 fb1824 1e6
R3_1824 out1824 fb1824 99934.4509
R4_1824 fb1824 0 22079.4416
Rl1824 out1824 0 10
Vr1825 ref1825 0 0.604829365
E1825 out1825 0 ref1825 fb1825 1e6
R3_1825 out1825 fb1825 100649.338
R4_1825 fb1825 0 21973.1174
Rl1825 out1825 0 10
Vr1826 ref1826 0 0.591083799
E1826 out1826 0 ref1826 fb1826 1e6
R3_1826 out1826 fb1826 100819.172
R4_1826 fb1826 0 22158.6797
Rl1826 out1826 0 10
Vr1827 ref1827 0 0.599616338
E1827 out1827 0 ref1827 fb1827 1e6
R3_1827 out1827 fb1827 99176.8411
R4_1827 fb1827 0 22033.3203
Rl1827 out1827 0 10
Vr1828 ref1828 0 0.598477969
E1828 out1828 0 ref1828 fb1828 1e6
R3_1828 out1828 fb1828 100198.697
R4_1828 fb1828 0 22028.5948
Rl1828 out1828 0 10
Vr1829 ref1829 0 0.605898525
E1829 out1829 0 ref1829 fb1829 1e6
R3_1829 out1829 fb1829 100805.474
R4_1829 fb1829 0 21834.3064
Rl1829 out1829 0 10
Vr1830 ref1830 0 0.588486734
E1830 out1830 0 ref1830 fb1830 1e6
R3_1830 out1830 fb1830 100065.907
R4_1830 fb1830 0 22181.5149
Rl1830 out1830 0 10
Vr1831 ref1831 0 0.607311376
E1831 out1831 0 ref1831 fb1831 1e6
R3_1831 out1831 fb1831 100938.504
R4_1831 fb1831 0 22049.8584
Rl1831 out1831 0 10
Vr1832 ref1832 0 0.609781862
E1832 out1832 0 ref1832 fb1832 1e6
R3_1832 out1832 fb1832 100373.894
R4_1832 fb1832 0 21843.5862
Rl1832 out1832 0 10
Vr1833 ref1833 0 0.607354581
E1833 out1833 0 ref1833 fb1833 1e6
R3_1833 out1833 fb1833 99333.0319
R4_1833 fb1833 0 21924.1735
Rl1833 out1833 0 10
Vr1834 ref1834 0 0.603413027
E1834 out1834 0 ref1834 fb1834 1e6
R3_1834 out1834 fb1834 100797.184
R4_1834 fb1834 0 21967.3973
Rl1834 out1834 0 10
Vr1835 ref1835 0 0.605246329
E1835 out1835 0 ref1835 fb1835 1e6
R3_1835 out1835 fb1835 100640.174
R4_1835 fb1835 0 21995.3968
Rl1835 out1835 0 10
Vr1836 ref1836 0 0.610732584
E1836 out1836 0 ref1836 fb1836 1e6
R3_1836 out1836 fb1836 100978.604
R4_1836 fb1836 0 21801.277
Rl1836 out1836 0 10
Vr1837 ref1837 0 0.58802693
E1837 out1837 0 ref1837 fb1837 1e6
R3_1837 out1837 fb1837 99472.8151
R4_1837 fb1837 0 21870.7768
Rl1837 out1837 0 10
Vr1838 ref1838 0 0.591610476
E1838 out1838 0 ref1838 fb1838 1e6
R3_1838 out1838 fb1838 99823.217
R4_1838 fb1838 0 22203.1386
Rl1838 out1838 0 10
Vr1839 ref1839 0 0.589382155
E1839 out1839 0 ref1839 fb1839 1e6
R3_1839 out1839 fb1839 100706.082
R4_1839 fb1839 0 21835.4833
Rl1839 out1839 0 10
Vr1840 ref1840 0 0.592602794
E1840 out1840 0 ref1840 fb1840 1e6
R3_1840 out1840 fb1840 99685.2107
R4_1840 fb1840 0 22114.1951
Rl1840 out1840 0 10
Vr1841 ref1841 0 0.596098251
E1841 out1841 0 ref1841 fb1841 1e6
R3_1841 out1841 fb1841 99209.722
R4_1841 fb1841 0 22072.5037
Rl1841 out1841 0 10
Vr1842 ref1842 0 0.606012302
E1842 out1842 0 ref1842 fb1842 1e6
R3_1842 out1842 fb1842 99327.0315
R4_1842 fb1842 0 21802.6435
Rl1842 out1842 0 10
Vr1843 ref1843 0 0.590712572
E1843 out1843 0 ref1843 fb1843 1e6
R3_1843 out1843 fb1843 100756.372
R4_1843 fb1843 0 22092.7422
Rl1843 out1843 0 10
Vr1844 ref1844 0 0.605610649
E1844 out1844 0 ref1844 fb1844 1e6
R3_1844 out1844 fb1844 100676.245
R4_1844 fb1844 0 21819.3876
Rl1844 out1844 0 10
Vr1845 ref1845 0 0.592957609
E1845 out1845 0 ref1845 fb1845 1e6
R3_1845 out1845 fb1845 100063.348
R4_1845 fb1845 0 21956.3116
Rl1845 out1845 0 10
Vr1846 ref1846 0 0.601965064
E1846 out1846 0 ref1846 fb1846 1e6
R3_1846 out1846 fb1846 99539.4529
R4_1846 fb1846 0 22040.0623
Rl1846 out1846 0 10
Vr1847 ref1847 0 0.605677493
E1847 out1847 0 ref1847 fb1847 1e6
R3_1847 out1847 fb1847 100331.909
R4_1847 fb1847 0 22153.1843
Rl1847 out1847 0 10
Vr1848 ref1848 0 0.606495187
E1848 out1848 0 ref1848 fb1848 1e6
R3_1848 out1848 fb1848 99086.8584
R4_1848 fb1848 0 21780.0803
Rl1848 out1848 0 10
Vr1849 ref1849 0 0.589625619
E1849 out1849 0 ref1849 fb1849 1e6
R3_1849 out1849 fb1849 99724.0138
R4_1849 fb1849 0 21955.9105
Rl1849 out1849 0 10
Vr1850 ref1850 0 0.596537136
E1850 out1850 0 ref1850 fb1850 1e6
R3_1850 out1850 fb1850 100376.952
R4_1850 fb1850 0 21956.375
Rl1850 out1850 0 10
Vr1851 ref1851 0 0.611727043
E1851 out1851 0 ref1851 fb1851 1e6
R3_1851 out1851 fb1851 100220.719
R4_1851 fb1851 0 21932.7525
Rl1851 out1851 0 10
Vr1852 ref1852 0 0.593709451
E1852 out1852 0 ref1852 fb1852 1e6
R3_1852 out1852 fb1852 100857.599
R4_1852 fb1852 0 22121.0223
Rl1852 out1852 0 10
Vr1853 ref1853 0 0.600716737
E1853 out1853 0 ref1853 fb1853 1e6
R3_1853 out1853 fb1853 100576.611
R4_1853 fb1853 0 22028.0315
Rl1853 out1853 0 10
Vr1854 ref1854 0 0.593124666
E1854 out1854 0 ref1854 fb1854 1e6
R3_1854 out1854 fb1854 99618.0261
R4_1854 fb1854 0 21805.6525
Rl1854 out1854 0 10
Vr1855 ref1855 0 0.603808857
E1855 out1855 0 ref1855 fb1855 1e6
R3_1855 out1855 fb1855 100104.238
R4_1855 fb1855 0 21901.6421
Rl1855 out1855 0 10
Vr1856 ref1856 0 0.604017032
E1856 out1856 0 ref1856 fb1856 1e6
R3_1856 out1856 fb1856 100706.848
R4_1856 fb1856 0 22047.3194
Rl1856 out1856 0 10
Vr1857 ref1857 0 0.604337246
E1857 out1857 0 ref1857 fb1857 1e6
R3_1857 out1857 fb1857 100539.94
R4_1857 fb1857 0 21917.2139
Rl1857 out1857 0 10
Vr1858 ref1858 0 0.592210928
E1858 out1858 0 ref1858 fb1858 1e6
R3_1858 out1858 fb1858 100883.493
R4_1858 fb1858 0 22150.8421
Rl1858 out1858 0 10
Vr1859 ref1859 0 0.599286468
E1859 out1859 0 ref1859 fb1859 1e6
R3_1859 out1859 fb1859 99819.5185
R4_1859 fb1859 0 21876.9454
Rl1859 out1859 0 10
Vr1860 ref1860 0 0.600867808
E1860 out1860 0 ref1860 fb1860 1e6
R3_1860 out1860 fb1860 99705.9924
R4_1860 fb1860 0 22186.7676
Rl1860 out1860 0 10
Vr1861 ref1861 0 0.601888197
E1861 out1861 0 ref1861 fb1861 1e6
R3_1861 out1861 fb1861 100113.841
R4_1861 fb1861 0 21947.7289
Rl1861 out1861 0 10
Vr1862 ref1862 0 0.606360578
E1862 out1862 0 ref1862 fb1862 1e6
R3_1862 out1862 fb1862 99708.568
R4_1862 fb1862 0 21784.2987
Rl1862 out1862 0 10
Vr1863 ref1863 0 0.610837131
E1863 out1863 0 ref1863 fb1863 1e6
R3_1863 out1863 fb1863 99445.737
R4_1863 fb1863 0 21895.0495
Rl1863 out1863 0 10
Vr1864 ref1864 0 0.601780746
E1864 out1864 0 ref1864 fb1864 1e6
R3_1864 out1864 fb1864 100468.68
R4_1864 fb1864 0 21922.7395
Rl1864 out1864 0 10
Vr1865 ref1865 0 0.600921569
E1865 out1865 0 ref1865 fb1865 1e6
R3_1865 out1865 fb1865 99025.2544
R4_1865 fb1865 0 21946.0028
Rl1865 out1865 0 10
Vr1866 ref1866 0 0.600613104
E1866 out1866 0 ref1866 fb1866 1e6
R3_1866 out1866 fb1866 100662.402
R4_1866 fb1866 0 21842.8471
Rl1866 out1866 0 10
Vr1867 ref1867 0 0.600447883
E1867 out1867 0 ref1867 fb1867 1e6
R3_1867 out1867 fb1867 100149.431
R4_1867 fb1867 0 22046.7936
Rl1867 out1867 0 10
Vr1868 ref1868 0 0.593914897
E1868 out1868 0 ref1868 fb1868 1e6
R3_1868 out1868 fb1868 99487.8374
R4_1868 fb1868 0 21953.8514
Rl1868 out1868 0 10
Vr1869 ref1869 0 0.609871806
E1869 out1869 0 ref1869 fb1869 1e6
R3_1869 out1869 fb1869 100834.084
R4_1869 fb1869 0 22069.885
Rl1869 out1869 0 10
Vr1870 ref1870 0 0.595339072
E1870 out1870 0 ref1870 fb1870 1e6
R3_1870 out1870 fb1870 99820.4208
R4_1870 fb1870 0 21922.5247
Rl1870 out1870 0 10
Vr1871 ref1871 0 0.589324254
E1871 out1871 0 ref1871 fb1871 1e6
R3_1871 out1871 fb1871 99965.6247
R4_1871 fb1871 0 22081.3087
Rl1871 out1871 0 10
Vr1872 ref1872 0 0.599146379
E1872 out1872 0 ref1872 fb1872 1e6
R3_1872 out1872 fb1872 99167.4669
R4_1872 fb1872 0 21982.6038
Rl1872 out1872 0 10
Vr1873 ref1873 0 0.610089448
E1873 out1873 0 ref1873 fb1873 1e6
R3_1873 out1873 fb1873 100203.027
R4_1873 fb1873 0 22202.578
Rl1873 out1873 0 10
Vr1874 ref1874 0 0.607126332
E1874 out1874 0 ref1874 fb1874 1e6
R3_1874 out1874 fb1874 100618.285
R4_1874 fb1874 0 22089.2908
Rl1874 out1874 0 10
Vr1875 ref1875 0 0.608509017
E1875 out1875 0 ref1875 fb1875 1e6
R3_1875 out1875 fb1875 100543.057
R4_1875 fb1875 0 22007.5504
Rl1875 out1875 0 10
Vr1876 ref1876 0 0.591151232
E1876 out1876 0 ref1876 fb1876 1e6
R3_1876 out1876 fb1876 100666.68
R4_1876 fb1876 0 22213.0392
Rl1876 out1876 0 10
Vr1877 ref1877 0 0.599670881
E1877 out1877 0 ref1877 fb1877 1e6
R3_1877 out1877 fb1877 100731.458
R4_1877 fb1877 0 21859.6376
Rl1877 out1877 0 10
Vr1878 ref1878 0 0.602106855
E1878 out1878 0 ref1878 fb1878 1e6
R3_1878 out1878 fb1878 99910.7948
R4_1878 fb1878 0 21931.4508
Rl1878 out1878 0 10
Vr1879 ref1879 0 0.607207358
E1879 out1879 0 ref1879 fb1879 1e6
R3_1879 out1879 fb1879 100962.543
R4_1879 fb1879 0 22096.4145
Rl1879 out1879 0 10
Vr1880 ref1880 0 0.604834797
E1880 out1880 0 ref1880 fb1880 1e6
R3_1880 out1880 fb1880 99286.4767
R4_1880 fb1880 0 22155.5237
Rl1880 out1880 0 10
Vr1881 ref1881 0 0.593267296
E1881 out1881 0 ref1881 fb1881 1e6
R3_1881 out1881 fb1881 99052.4365
R4_1881 fb1881 0 22204.3868
Rl1881 out1881 0 10
Vr1882 ref1882 0 0.588512663
E1882 out1882 0 ref1882 fb1882 1e6
R3_1882 out1882 fb1882 100201.738
R4_1882 fb1882 0 22120.771
Rl1882 out1882 0 10
Vr1883 ref1883 0 0.592807289
E1883 out1883 0 ref1883 fb1883 1e6
R3_1883 out1883 fb1883 100115.949
R4_1883 fb1883 0 21987.0386
Rl1883 out1883 0 10
Vr1884 ref1884 0 0.611333971
E1884 out1884 0 ref1884 fb1884 1e6
R3_1884 out1884 fb1884 99669.3879
R4_1884 fb1884 0 21962.1783
Rl1884 out1884 0 10
Vr1885 ref1885 0 0.600534128
E1885 out1885 0 ref1885 fb1885 1e6
R3_1885 out1885 fb1885 100127.645
R4_1885 fb1885 0 22037.5581
Rl1885 out1885 0 10
Vr1886 ref1886 0 0.597157631
E1886 out1886 0 ref1886 fb1886 1e6
R3_1886 out1886 fb1886 99132.4033
R4_1886 fb1886 0 21823.9314
Rl1886 out1886 0 10
Vr1887 ref1887 0 0.604513547
E1887 out1887 0 ref1887 fb1887 1e6
R3_1887 out1887 fb1887 100796.857
R4_1887 fb1887 0 21909.9309
Rl1887 out1887 0 10
Vr1888 ref1888 0 0.58853766
E1888 out1888 0 ref1888 fb1888 1e6
R3_1888 out1888 fb1888 100974.286
R4_1888 fb1888 0 22009.9181
Rl1888 out1888 0 10
Vr1889 ref1889 0 0.594225363
E1889 out1889 0 ref1889 fb1889 1e6
R3_1889 out1889 fb1889 100389.566
R4_1889 fb1889 0 22108.5733
Rl1889 out1889 0 10
Vr1890 ref1890 0 0.610607353
E1890 out1890 0 ref1890 fb1890 1e6
R3_1890 out1890 fb1890 100910.042
R4_1890 fb1890 0 22120.0042
Rl1890 out1890 0 10
Vr1891 ref1891 0 0.598548766
E1891 out1891 0 ref1891 fb1891 1e6
R3_1891 out1891 fb1891 99905.2129
R4_1891 fb1891 0 22073.5275
Rl1891 out1891 0 10
Vr1892 ref1892 0 0.59399135
E1892 out1892 0 ref1892 fb1892 1e6
R3_1892 out1892 fb1892 99166.2487
R4_1892 fb1892 0 21841.0843
Rl1892 out1892 0 10
Vr1893 ref1893 0 0.594719069
E1893 out1893 0 ref1893 fb1893 1e6
R3_1893 out1893 fb1893 99149.3442
R4_1893 fb1893 0 22193.1905
Rl1893 out1893 0 10
Vr1894 ref1894 0 0.606923487
E1894 out1894 0 ref1894 fb1894 1e6
R3_1894 out1894 fb1894 99478.3393
R4_1894 fb1894 0 22032.3792
Rl1894 out1894 0 10
Vr1895 ref1895 0 0.608970586
E1895 out1895 0 ref1895 fb1895 1e6
R3_1895 out1895 fb1895 99102.7163
R4_1895 fb1895 0 21929.1278
Rl1895 out1895 0 10
Vr1896 ref1896 0 0.598990389
E1896 out1896 0 ref1896 fb1896 1e6
R3_1896 out1896 fb1896 100665.049
R4_1896 fb1896 0 21858.1283
Rl1896 out1896 0 10
Vr1897 ref1897 0 0.606467305
E1897 out1897 0 ref1897 fb1897 1e6
R3_1897 out1897 fb1897 99971.7412
R4_1897 fb1897 0 21989.7121
Rl1897 out1897 0 10
Vr1898 ref1898 0 0.608985806
E1898 out1898 0 ref1898 fb1898 1e6
R3_1898 out1898 fb1898 100266.401
R4_1898 fb1898 0 21939.8539
Rl1898 out1898 0 10
Vr1899 ref1899 0 0.590115312
E1899 out1899 0 ref1899 fb1899 1e6
R3_1899 out1899 fb1899 100021.722
R4_1899 fb1899 0 21913.4524
Rl1899 out1899 0 10
Vr1900 ref1900 0 0.595854816
E1900 out1900 0 ref1900 fb1900 1e6
R3_1900 out1900 fb1900 100482.198
R4_1900 fb1900 0 22132.7506
Rl1900 out1900 0 10
Vr1901 ref1901 0 0.60508751
E1901 out1901 0 ref1901 fb1901 1e6
R3_1901 out1901 fb1901 99008.3875
R4_1901 fb1901 0 22042.2779
Rl1901 out1901 0 10
Vr1902 ref1902 0 0.589914397
E1902 out1902 0 ref1902 fb1902 1e6
R3_1902 out1902 fb1902 100972.399
R4_1902 fb1902 0 21974.6017
Rl1902 out1902 0 10
Vr1903 ref1903 0 0.611667264
E1903 out1903 0 ref1903 fb1903 1e6
R3_1903 out1903 fb1903 99814.2825
R4_1903 fb1903 0 21904.1592
Rl1903 out1903 0 10
Vr1904 ref1904 0 0.594603316
E1904 out1904 0 ref1904 fb1904 1e6
R3_1904 out1904 fb1904 99654.2205
R4_1904 fb1904 0 22204.3229
Rl1904 out1904 0 10
Vr1905 ref1905 0 0.60058425
E1905 out1905 0 ref1905 fb1905 1e6
R3_1905 out1905 fb1905 100429.905
R4_1905 fb1905 0 22206.3953
Rl1905 out1905 0 10
Vr1906 ref1906 0 0.594505767
E1906 out1906 0 ref1906 fb1906 1e6
R3_1906 out1906 fb1906 99392.3315
R4_1906 fb1906 0 22199.7536
Rl1906 out1906 0 10
Vr1907 ref1907 0 0.603093784
E1907 out1907 0 ref1907 fb1907 1e6
R3_1907 out1907 fb1907 99987.5797
R4_1907 fb1907 0 21863.1777
Rl1907 out1907 0 10
Vr1908 ref1908 0 0.603619006
E1908 out1908 0 ref1908 fb1908 1e6
R3_1908 out1908 fb1908 99171.4902
R4_1908 fb1908 0 22117.1389
Rl1908 out1908 0 10
Vr1909 ref1909 0 0.611703164
E1909 out1909 0 ref1909 fb1909 1e6
R3_1909 out1909 fb1909 99502.5372
R4_1909 fb1909 0 21973.4588
Rl1909 out1909 0 10
Vr1910 ref1910 0 0.607224605
E1910 out1910 0 ref1910 fb1910 1e6
R3_1910 out1910 fb1910 99673.2186
R4_1910 fb1910 0 22022.3982
Rl1910 out1910 0 10
Vr1911 ref1911 0 0.610608707
E1911 out1911 0 ref1911 fb1911 1e6
R3_1911 out1911 fb1911 100763.14
R4_1911 fb1911 0 22081.5597
Rl1911 out1911 0 10
Vr1912 ref1912 0 0.608468439
E1912 out1912 0 ref1912 fb1912 1e6
R3_1912 out1912 fb1912 99710.3273
R4_1912 fb1912 0 22018.5845
Rl1912 out1912 0 10
Vr1913 ref1913 0 0.605457563
E1913 out1913 0 ref1913 fb1913 1e6
R3_1913 out1913 fb1913 100670.79
R4_1913 fb1913 0 21844.8584
Rl1913 out1913 0 10
Vr1914 ref1914 0 0.594648918
E1914 out1914 0 ref1914 fb1914 1e6
R3_1914 out1914 fb1914 100889.152
R4_1914 fb1914 0 21883.8511
Rl1914 out1914 0 10
Vr1915 ref1915 0 0.610004315
E1915 out1915 0 ref1915 fb1915 1e6
R3_1915 out1915 fb1915 100799.244
R4_1915 fb1915 0 22049.4005
Rl1915 out1915 0 10
Vr1916 ref1916 0 0.598359607
E1916 out1916 0 ref1916 fb1916 1e6
R3_1916 out1916 fb1916 99204.5645
R4_1916 fb1916 0 22189.7265
Rl1916 out1916 0 10
Vr1917 ref1917 0 0.589297919
E1917 out1917 0 ref1917 fb1917 1e6
R3_1917 out1917 fb1917 100978.008
R4_1917 fb1917 0 22204.7822
Rl1917 out1917 0 10
Vr1918 ref1918 0 0.605924048
E1918 out1918 0 ref1918 fb1918 1e6
R3_1918 out1918 fb1918 99901.9143
R4_1918 fb1918 0 21895.7119
Rl1918 out1918 0 10
Vr1919 ref1919 0 0.607210013
E1919 out1919 0 ref1919 fb1919 1e6
R3_1919 out1919 fb1919 99231.2403
R4_1919 fb1919 0 21814.8644
Rl1919 out1919 0 10
Vr1920 ref1920 0 0.609693462
E1920 out1920 0 ref1920 fb1920 1e6
R3_1920 out1920 fb1920 100393.351
R4_1920 fb1920 0 21860.4719
Rl1920 out1920 0 10
Vr1921 ref1921 0 0.595480528
E1921 out1921 0 ref1921 fb1921 1e6
R3_1921 out1921 fb1921 99437.0298
R4_1921 fb1921 0 22057.6596
Rl1921 out1921 0 10
Vr1922 ref1922 0 0.609275935
E1922 out1922 0 ref1922 fb1922 1e6
R3_1922 out1922 fb1922 99061.6505
R4_1922 fb1922 0 21855.712
Rl1922 out1922 0 10
Vr1923 ref1923 0 0.606832497
E1923 out1923 0 ref1923 fb1923 1e6
R3_1923 out1923 fb1923 100615.103
R4_1923 fb1923 0 22179.9031
Rl1923 out1923 0 10
Vr1924 ref1924 0 0.59982739
E1924 out1924 0 ref1924 fb1924 1e6
R3_1924 out1924 fb1924 100941.302
R4_1924 fb1924 0 21794.6127
Rl1924 out1924 0 10
Vr1925 ref1925 0 0.591827274
E1925 out1925 0 ref1925 fb1925 1e6
R3_1925 out1925 fb1925 99109.469
R4_1925 fb1925 0 22187.4595
Rl1925 out1925 0 10
Vr1926 ref1926 0 0.608434876
E1926 out1926 0 ref1926 fb1926 1e6
R3_1926 out1926 fb1926 99436.854
R4_1926 fb1926 0 21911.845
Rl1926 out1926 0 10
Vr1927 ref1927 0 0.595492378
E1927 out1927 0 ref1927 fb1927 1e6
R3_1927 out1927 fb1927 99630.3131
R4_1927 fb1927 0 22158.2042
Rl1927 out1927 0 10
Vr1928 ref1928 0 0.603559553
E1928 out1928 0 ref1928 fb1928 1e6
R3_1928 out1928 fb1928 99003.1332
R4_1928 fb1928 0 22025.2758
Rl1928 out1928 0 10
Vr1929 ref1929 0 0.588021104
E1929 out1929 0 ref1929 fb1929 1e6
R3_1929 out1929 fb1929 99841.2945
R4_1929 fb1929 0 21937.3761
Rl1929 out1929 0 10
Vr1930 ref1930 0 0.602049362
E1930 out1930 0 ref1930 fb1930 1e6
R3_1930 out1930 fb1930 100694.224
R4_1930 fb1930 0 22207.4172
Rl1930 out1930 0 10
Vr1931 ref1931 0 0.596954658
E1931 out1931 0 ref1931 fb1931 1e6
R3_1931 out1931 fb1931 100342.701
R4_1931 fb1931 0 21789.8833
Rl1931 out1931 0 10
Vr1932 ref1932 0 0.606373366
E1932 out1932 0 ref1932 fb1932 1e6
R3_1932 out1932 fb1932 100815.681
R4_1932 fb1932 0 21956.4606
Rl1932 out1932 0 10
Vr1933 ref1933 0 0.610263131
E1933 out1933 0 ref1933 fb1933 1e6
R3_1933 out1933 fb1933 99478.5844
R4_1933 fb1933 0 21869.5033
Rl1933 out1933 0 10
Vr1934 ref1934 0 0.595871659
E1934 out1934 0 ref1934 fb1934 1e6
R3_1934 out1934 fb1934 100645.824
R4_1934 fb1934 0 22043.0031
Rl1934 out1934 0 10
Vr1935 ref1935 0 0.600195337
E1935 out1935 0 ref1935 fb1935 1e6
R3_1935 out1935 fb1935 99072.222
R4_1935 fb1935 0 21809.8877
Rl1935 out1935 0 10
Vr1936 ref1936 0 0.605732901
E1936 out1936 0 ref1936 fb1936 1e6
R3_1936 out1936 fb1936 99001.7752
R4_1936 fb1936 0 21805.669
Rl1936 out1936 0 10
Vr1937 ref1937 0 0.610892921
E1937 out1937 0 ref1937 fb1937 1e6
R3_1937 out1937 fb1937 100102.004
R4_1937 fb1937 0 21862.9935
Rl1937 out1937 0 10
Vr1938 ref1938 0 0.59837115
E1938 out1938 0 ref1938 fb1938 1e6
R3_1938 out1938 fb1938 99942.8985
R4_1938 fb1938 0 21920.299
Rl1938 out1938 0 10
Vr1939 ref1939 0 0.609019562
E1939 out1939 0 ref1939 fb1939 1e6
R3_1939 out1939 fb1939 100812.074
R4_1939 fb1939 0 21803.2577
Rl1939 out1939 0 10
Vr1940 ref1940 0 0.594870008
E1940 out1940 0 ref1940 fb1940 1e6
R3_1940 out1940 fb1940 100941.701
R4_1940 fb1940 0 21884.7474
Rl1940 out1940 0 10
Vr1941 ref1941 0 0.604356933
E1941 out1941 0 ref1941 fb1941 1e6
R3_1941 out1941 fb1941 100915.038
R4_1941 fb1941 0 22061.1293
Rl1941 out1941 0 10
Vr1942 ref1942 0 0.597826534
E1942 out1942 0 ref1942 fb1942 1e6
R3_1942 out1942 fb1942 100962.909
R4_1942 fb1942 0 22105.9854
Rl1942 out1942 0 10
Vr1943 ref1943 0 0.591488147
E1943 out1943 0 ref1943 fb1943 1e6
R3_1943 out1943 fb1943 99612.2498
R4_1943 fb1943 0 21867.8255
Rl1943 out1943 0 10
Vr1944 ref1944 0 0.598496996
E1944 out1944 0 ref1944 fb1944 1e6
R3_1944 out1944 fb1944 99315.0432
R4_1944 fb1944 0 21857.3668
Rl1944 out1944 0 10
Vr1945 ref1945 0 0.605937467
E1945 out1945 0 ref1945 fb1945 1e6
R3_1945 out1945 fb1945 100975.331
R4_1945 fb1945 0 22101.8167
Rl1945 out1945 0 10
Vr1946 ref1946 0 0.592816139
E1946 out1946 0 ref1946 fb1946 1e6
R3_1946 out1946 fb1946 99172.1724
R4_1946 fb1946 0 21996.9922
Rl1946 out1946 0 10
Vr1947 ref1947 0 0.604614045
E1947 out1947 0 ref1947 fb1947 1e6
R3_1947 out1947 fb1947 100738.103
R4_1947 fb1947 0 21845.7089
Rl1947 out1947 0 10
Vr1948 ref1948 0 0.591003848
E1948 out1948 0 ref1948 fb1948 1e6
R3_1948 out1948 fb1948 100789.216
R4_1948 fb1948 0 21909.878
Rl1948 out1948 0 10
Vr1949 ref1949 0 0.593244981
E1949 out1949 0 ref1949 fb1949 1e6
R3_1949 out1949 fb1949 99153.4306
R4_1949 fb1949 0 22069.9265
Rl1949 out1949 0 10
Vr1950 ref1950 0 0.591461813
E1950 out1950 0 ref1950 fb1950 1e6
R3_1950 out1950 fb1950 100763.909
R4_1950 fb1950 0 21834.5464
Rl1950 out1950 0 10
Vr1951 ref1951 0 0.606694414
E1951 out1951 0 ref1951 fb1951 1e6
R3_1951 out1951 fb1951 99068.9501
R4_1951 fb1951 0 22154.5578
Rl1951 out1951 0 10
Vr1952 ref1952 0 0.600552789
E1952 out1952 0 ref1952 fb1952 1e6
R3_1952 out1952 fb1952 99765.7723
R4_1952 fb1952 0 22013.0655
Rl1952 out1952 0 10
Vr1953 ref1953 0 0.589056802
E1953 out1953 0 ref1953 fb1953 1e6
R3_1953 out1953 fb1953 99293.1446
R4_1953 fb1953 0 22205.3281
Rl1953 out1953 0 10
Vr1954 ref1954 0 0.603532046
E1954 out1954 0 ref1954 fb1954 1e6
R3_1954 out1954 fb1954 100784.831
R4_1954 fb1954 0 21961.01
Rl1954 out1954 0 10
Vr1955 ref1955 0 0.588381215
E1955 out1955 0 ref1955 fb1955 1e6
R3_1955 out1955 fb1955 99155.1566
R4_1955 fb1955 0 22079.2187
Rl1955 out1955 0 10
Vr1956 ref1956 0 0.598953168
E1956 out1956 0 ref1956 fb1956 1e6
R3_1956 out1956 fb1956 99965.7148
R4_1956 fb1956 0 22180.518
Rl1956 out1956 0 10
Vr1957 ref1957 0 0.611342252
E1957 out1957 0 ref1957 fb1957 1e6
R3_1957 out1957 fb1957 100405.56
R4_1957 fb1957 0 21853.1441
Rl1957 out1957 0 10
Vr1958 ref1958 0 0.601177375
E1958 out1958 0 ref1958 fb1958 1e6
R3_1958 out1958 fb1958 100978.017
R4_1958 fb1958 0 22119.7251
Rl1958 out1958 0 10
Vr1959 ref1959 0 0.591901207
E1959 out1959 0 ref1959 fb1959 1e6
R3_1959 out1959 fb1959 99358.8947
R4_1959 fb1959 0 22045.8901
Rl1959 out1959 0 10
Vr1960 ref1960 0 0.607388397
E1960 out1960 0 ref1960 fb1960 1e6
R3_1960 out1960 fb1960 99706.8602
R4_1960 fb1960 0 22085.1895
Rl1960 out1960 0 10
Vr1961 ref1961 0 0.611018175
E1961 out1961 0 ref1961 fb1961 1e6
R3_1961 out1961 fb1961 100434.288
R4_1961 fb1961 0 21838.3138
Rl1961 out1961 0 10
Vr1962 ref1962 0 0.593471679
E1962 out1962 0 ref1962 fb1962 1e6
R3_1962 out1962 fb1962 99526.7888
R4_1962 fb1962 0 22023.4209
Rl1962 out1962 0 10
Vr1963 ref1963 0 0.596326126
E1963 out1963 0 ref1963 fb1963 1e6
R3_1963 out1963 fb1963 99060.8768
R4_1963 fb1963 0 21956.689
Rl1963 out1963 0 10
Vr1964 ref1964 0 0.590865997
E1964 out1964 0 ref1964 fb1964 1e6
R3_1964 out1964 fb1964 99911.7859
R4_1964 fb1964 0 21834.8822
Rl1964 out1964 0 10
Vr1965 ref1965 0 0.594170905
E1965 out1965 0 ref1965 fb1965 1e6
R3_1965 out1965 fb1965 99465.7684
R4_1965 fb1965 0 22178.5757
Rl1965 out1965 0 10
Vr1966 ref1966 0 0.604751687
E1966 out1966 0 ref1966 fb1966 1e6
R3_1966 out1966 fb1966 99323.938
R4_1966 fb1966 0 21904.0279
Rl1966 out1966 0 10
Vr1967 ref1967 0 0.603514991
E1967 out1967 0 ref1967 fb1967 1e6
R3_1967 out1967 fb1967 100581.053
R4_1967 fb1967 0 21790.9306
Rl1967 out1967 0 10
Vr1968 ref1968 0 0.599689838
E1968 out1968 0 ref1968 fb1968 1e6
R3_1968 out1968 fb1968 99162.374
R4_1968 fb1968 0 22013.2851
Rl1968 out1968 0 10
Vr1969 ref1969 0 0.611607151
E1969 out1969 0 ref1969 fb1969 1e6
R3_1969 out1969 fb1969 100375.697
R4_1969 fb1969 0 22126.1817
Rl1969 out1969 0 10
Vr1970 ref1970 0 0.605790559
E1970 out1970 0 ref1970 fb1970 1e6
R3_1970 out1970 fb1970 100366.448
R4_1970 fb1970 0 22215.8112
Rl1970 out1970 0 10
Vr1971 ref1971 0 0.591016021
E1971 out1971 0 ref1971 fb1971 1e6
R3_1971 out1971 fb1971 100051.119
R4_1971 fb1971 0 22092.5674
Rl1971 out1971 0 10
Vr1972 ref1972 0 0.595231517
E1972 out1972 0 ref1972 fb1972 1e6
R3_1972 out1972 fb1972 99203.1104
R4_1972 fb1972 0 21826.8434
Rl1972 out1972 0 10
Vr1973 ref1973 0 0.600542461
E1973 out1973 0 ref1973 fb1973 1e6
R3_1973 out1973 fb1973 100450.081
R4_1973 fb1973 0 22172.7058
Rl1973 out1973 0 10
Vr1974 ref1974 0 0.595577857
E1974 out1974 0 ref1974 fb1974 1e6
R3_1974 out1974 fb1974 100837.911
R4_1974 fb1974 0 22164.7594
Rl1974 out1974 0 10
Vr1975 ref1975 0 0.59048871
E1975 out1975 0 ref1975 fb1975 1e6
R3_1975 out1975 fb1975 99028.6775
R4_1975 fb1975 0 21862.9217
Rl1975 out1975 0 10
Vr1976 ref1976 0 0.610806855
E1976 out1976 0 ref1976 fb1976 1e6
R3_1976 out1976 fb1976 100045.058
R4_1976 fb1976 0 22046.6499
Rl1976 out1976 0 10
Vr1977 ref1977 0 0.607026763
E1977 out1977 0 ref1977 fb1977 1e6
R3_1977 out1977 fb1977 100502.466
R4_1977 fb1977 0 21787.4316
Rl1977 out1977 0 10
Vr1978 ref1978 0 0.601280705
E1978 out1978 0 ref1978 fb1978 1e6
R3_1978 out1978 fb1978 99992.6661
R4_1978 fb1978 0 22214.4361
Rl1978 out1978 0 10
Vr1979 ref1979 0 0.601186528
E1979 out1979 0 ref1979 fb1979 1e6
R3_1979 out1979 fb1979 99995.7423
R4_1979 fb1979 0 22020.7525
Rl1979 out1979 0 10
Vr1980 ref1980 0 0.607197647
E1980 out1980 0 ref1980 fb1980 1e6
R3_1980 out1980 fb1980 99149.7193
R4_1980 fb1980 0 22189.4058
Rl1980 out1980 0 10
Vr1981 ref1981 0 0.590173399
E1981 out1981 0 ref1981 fb1981 1e6
R3_1981 out1981 fb1981 100749.711
R4_1981 fb1981 0 22084.516
Rl1981 out1981 0 10
Vr1982 ref1982 0 0.611833494
E1982 out1982 0 ref1982 fb1982 1e6
R3_1982 out1982 fb1982 100878.685
R4_1982 fb1982 0 21987.8468
Rl1982 out1982 0 10
Vr1983 ref1983 0 0.588432747
E1983 out1983 0 ref1983 fb1983 1e6
R3_1983 out1983 fb1983 99639.1726
R4_1983 fb1983 0 22056.573
Rl1983 out1983 0 10
Vr1984 ref1984 0 0.60944314
E1984 out1984 0 ref1984 fb1984 1e6
R3_1984 out1984 fb1984 99555.7239
R4_1984 fb1984 0 21910.1053
Rl1984 out1984 0 10
Vr1985 ref1985 0 0.599489237
E1985 out1985 0 ref1985 fb1985 1e6
R3_1985 out1985 fb1985 100744.348
R4_1985 fb1985 0 21937.6263
Rl1985 out1985 0 10
Vr1986 ref1986 0 0.60431362
E1986 out1986 0 ref1986 fb1986 1e6
R3_1986 out1986 fb1986 100234.197
R4_1986 fb1986 0 22019.062
Rl1986 out1986 0 10
Vr1987 ref1987 0 0.598877612
E1987 out1987 0 ref1987 fb1987 1e6
R3_1987 out1987 fb1987 100771.573
R4_1987 fb1987 0 21827.169
Rl1987 out1987 0 10
Vr1988 ref1988 0 0.588580772
E1988 out1988 0 ref1988 fb1988 1e6
R3_1988 out1988 fb1988 100659.026
R4_1988 fb1988 0 22071.1165
Rl1988 out1988 0 10
Vr1989 ref1989 0 0.611628463
E1989 out1989 0 ref1989 fb1989 1e6
R3_1989 out1989 fb1989 100420.888
R4_1989 fb1989 0 21789.5099
Rl1989 out1989 0 10
Vr1990 ref1990 0 0.608099417
E1990 out1990 0 ref1990 fb1990 1e6
R3_1990 out1990 fb1990 99174.8285
R4_1990 fb1990 0 21845.3801
Rl1990 out1990 0 10
Vr1991 ref1991 0 0.589096294
E1991 out1991 0 ref1991 fb1991 1e6
R3_1991 out1991 fb1991 100175.185
R4_1991 fb1991 0 21867.4194
Rl1991 out1991 0 10
Vr1992 ref1992 0 0.606169297
E1992 out1992 0 ref1992 fb1992 1e6
R3_1992 out1992 fb1992 100369.982
R4_1992 fb1992 0 22028.7392
Rl1992 out1992 0 10
Vr1993 ref1993 0 0.609468807
E1993 out1993 0 ref1993 fb1993 1e6
R3_1993 out1993 fb1993 100182.666
R4_1993 fb1993 0 22173.7476
Rl1993 out1993 0 10
Vr1994 ref1994 0 0.591123192
E1994 out1994 0 ref1994 fb1994 1e6
R3_1994 out1994 fb1994 100021.169
R4_1994 fb1994 0 21894.3702
Rl1994 out1994 0 10
Vr1995 ref1995 0 0.60445201
E1995 out1995 0 ref1995 fb1995 1e6
R3_1995 out1995 fb1995 100676.958
R4_1995 fb1995 0 21954.9815
Rl1995 out1995 0 10
Vr1996 ref1996 0 0.605148861
E1996 out1996 0 ref1996 fb1996 1e6
R3_1996 out1996 fb1996 100943.367
R4_1996 fb1996 0 21952.3473
Rl1996 out1996 0 10
Vr1997 ref1997 0 0.592587065
E1997 out1997 0 ref1997 fb1997 1e6
R3_1997 out1997 fb1997 100556.979
R4_1997 fb1997 0 22205.4153
Rl1997 out1997 0 10
Vr1998 ref1998 0 0.604853733
E1998 out1998 0 ref1998 fb1998 1e6
R3_1998 out1998 fb1998 99804.2815
R4_1998 fb1998 0 22161.485
Rl1998 out1998 0 10
Vr1999 ref1999 0 0.588039351
E1999 out1999 0 ref1999 fb1999 1e6
R3_1999 out1999 fb1999 100338.555
R4_1999 fb1999 0 21911.0627
Rl1999 out1999 0 10
.op
.end
