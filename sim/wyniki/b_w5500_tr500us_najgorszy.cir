* b) RSTn W5500: R61/C39 z obwod.py + RPU wewnętrzny, Tr = 0.5 ms
Vdd vdd 0 PWL(0 0 0.0005 3.3)
R61 vdd rst 9900
Rpu vdd rst 50000
C39 rst 0 5e-07
Iupl 0 rst 1e-06
.tran 3.125e-07 0.0252913189 0 1.25e-06
.end
